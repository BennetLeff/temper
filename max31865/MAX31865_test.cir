* MAX31865 RTD-to-Digital Converter Test Circuit
* Maxim Integrated (Analog Devices)
* Typical application: PT100 RTD temperature measurement with 4-wire connection

.title MAX31865 RTD-to-Digital Converter Test Circuit

***************************************************************************
* Include MAX31865 Model
***************************************************************************
.include MAX31865.lib

***************************************************************************
* Power Supplies
***************************************************************************
V_VDD VDD_NODE 0 DC 3.3
V_DVDD DVDD_NODE 0 DC 3.3

***************************************************************************
* MAX31865 RTD-to-Digital Converter
***************************************************************************
X_MAX31865 DRDY_NODE DVDD_NODE VDD_NODE BIAS_NODE
+ REFIN+_NODE REFIN-_NODE ISENSOR_NODE
+ FORCE+_NODE FORCE2_NODE RTDIN+_NODE RTDIN-_NODE FORCE-_NODE
+ GND2_NODE SDI_NODE SCLK_NODE CS_NODE SDO_NODE DGND_NODE GND1_NODE NC_NODE
+ MAX31865

***************************************************************************
* Power Supply Bypass Capacitors
***************************************************************************
CVDD_BULK VDD_NODE 0 10u IC=0
CVDD_CERAMIC VDD_NODE 0 0.1u IC=0
CDVDD_BULK DVDD_NODE 0 10u IC=0
CDVDD_CERAMIC DVDD_NODE 0 0.1u IC=0

***************************************************************************
* Reference Resistor (400 ohm for PT100)
***************************************************************************
R_REFIN+ BIAS_NODE REFIN+_NODE 0.001
RREF REFIN+_NODE REFIN-_NODE 400
R_ISENSOR ISENSOR_NODE REFIN-_NODE 0.001

* Connection from Reference Low to RTD High (Force+)
R_LINK REFIN-_NODE FORCE+_NODE 0.001

***************************************************************************
* PT100 RTD Sensor Model (109.73 ohm @ 25C)
***************************************************************************
R_RTD RTDIN+_NODE N_RTD_LOW R={100 + 0.385*25}

* Cable resistance
RCABLE_FP FORCE+_NODE RTDIN+_NODE 0.1
RCABLE_FN FORCE-_NODE N_RTD_LOW 0.1
RCABLE_RP RTDIN+_NODE RTDIN+_NODE 0.01
RCABLE_RN N_RTD_LOW RTDIN-_NODE 0.01

* Input Filter
CRTD_FILTER RTDIN+_NODE RTDIN-_NODE 100n IC=0

* 3-Wire Connection (Unused)
R_FORCE2_GND FORCE2_NODE 0 0.001

***************************************************************************
* SPI Interface (Static)
***************************************************************************
VCS CS_NODE 0 DC 3.3
RSCLK SCLK_NODE 0 1MEG
RSDI SDI_NODE 0 1MEG
RSDO_PULLDOWN SDO_NODE 0 100k
R_DRDY DRDY_NODE 0 1MEG

***************************************************************************
* Ground Connections
***************************************************************************
R_GND1_0 GND1_NODE 0 0.001
R_GND2_0 GND2_NODE 0 0.001
R_DGND_0 DGND_NODE 0 0.001
R_NC NC_NODE 0 1MEG

***************************************************************************
* Simulation Control
***************************************************************************
.op
.tran 1m 100m 0 100u
.ic V(BIAS_NODE)=0 V(REFIN+_NODE)=0

***************************************************************************
* Measurements and Analysis
***************************************************************************
.control
run

echo "===== MAX31865 Test Results ====="
echo "Conditions: PT100, 4-wire, 25C"

* Measure voltages at end of simulation
let v_bias_final = v(bias_node)[length(v(bias_node))-1]
print v_bias_final

* Calculate VRTD and VREF
let v_rtd = v(rtdin+_node) - v(rtdin-_node)
let v_ref = v(refin+_node) - v(refin-_node)

let v_rtd_final = v_rtd[length(v_rtd)-1]
let v_ref_final = v_ref[length(v_ref)-1]

print v_rtd_final
print v_ref_final

* Calculate Code
let adc_code = 32768 * v_rtd_final / v_ref_final
print adc_code

* Calculate Temperature
let temp_calc = (adc_code / 32) - 256
print temp_calc

echo "Expected Temp: ~25C"
.endc
.end
