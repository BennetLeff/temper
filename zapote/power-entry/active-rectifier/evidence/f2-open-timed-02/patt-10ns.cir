F2 open timed-model prescribed-pattern cross-check, numerical oracle only
* ON 0-4us, OFF 4-8us, ON 8-12us, latched OFF after 12us. Const crest Vin.
* V0=389.615V I0=23.2318A, 180u/470n + 1.013M. Ideal SW + synthetic diode.
.param vin=169.705627485 v0=389.6153846 i0=23.231838319 ll=180u cc=470n rdiv=1.013meg
Vline line 0 DC {vin}
Lboost line anode {ll} IC={i0}
Sboost anode 0 gon 0 SWMOD
Vgate gon 0 PWL(0 5 3.99u 5 4.01u 0 7.99u 0 8.01u 5 11.99u 5 12.01u 0 200u 0)
.model SWMOD SW(Ron=1m Roff=1G Vt=2.5 Vh=0.1)
Dboost anode out DSYN
.model DSYN D(IS=1e-12 N=1 RS=0.001 CJO=10p TT=0)
Cout out 0 {cc} IC={v0}
Rdiv out 0 {rdiv}
Rleak out 0 1e12
.options reltol=1e-7 abstol=1e-12 vntol=1e-8 method=gear
.tran 20n 80u 0 10n UIC
.measure tran vpeak MAX v(out)
.control
set noaskquit
run
set wr_singlescale
set wr_vecnames
wrdata patt-10ns.dat v(out) i(Lboost) v(anode)
quit
.endc
.end
