F2 open timed-model freewheel cross-check, independent numerical oracle only
* Freewheel from V0=425V I0=20A, const crest Vin, 180u/470n + 1.013M divider.
* Switch branch absent (already off). Synthetic diode, not a C3D20065D model.
.param vin=169.705627485 v0=425 i0=20 ll=180u cc=470n rdiv=1.013meg
Vline line 0 DC {vin}
Lboost line anode {ll} IC={i0}
Dboost anode out DSYN
.model DSYN D(IS=1e-12 N=1 RS=0.001 CJO=10p TT=0)
Cout out 0 {cc} IC={v0}
Rdiv out 0 {rdiv}
Rleak out 0 1e12
.options reltol=1e-7 abstol=1e-12 vntol=1e-8 method=gear
.tran 20n 60u 0 10n UIC
.measure tran vpeak MAX v(out)
.control
set noaskquit
run
set wr_singlescale
set wr_vecnames
wrdata freewheel-10ns.dat v(out) i(Lboost) v(anode)
quit
.endc
.end
