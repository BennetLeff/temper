* F2 shutdown transient model with finite-conductance power devices.  The
* exact STW65N65DM2AG and C3D20065D manufacturer SPICE files were unavailable
* after bounded retrieval attempts; this is a source-bound physical surrogate,
* not a manufacturer-qualified macro-model.
* Placeholders are substituted by run_cases.sh for each scenario.
.title F2 shutdown full signal path
.param VLINE=186.6761902
.param LBOOST=216u
.param IINIT=75
.param PW_ON=5.5u
.param PWM_DELAY=3u
.param CLOCAL=19.8u
.param VB_INIT=410
.param VD_INIT=410
.param DIV_INIT=2.403456820
.param T_OPEN=220u
.param T_CLOSE=500u
.param T_ARM=1u
.param ARM_HOLD=1.5u
.param T_ARM2=1u
.param ARM2=0
.param PERMIT_DROP=400u
.param PERMIT_RETURN=410u
.param RAIL_DROP=400u
.param RAIL_RETURN=410u
.param GATE_TAU=120n
.param TSTOP=320u
.param TSTEP=2n

* Device constants are tied to the retained data sheets.  STW: 0.05 ohm
* RDS(on) max at 10 V, Qg=120 nC, Qgs=27 nC, Qgd=58 nC, charging-time-equivalent Coss=456 pF,
* VGS(th)=3..5 V.  The gate capacitor is Qg/10 V; Cgd=Qgd/520 V and Coss
* are explicit energy paths.  C3D: VF~1.5 V at 10 A, C400V=40 pF,
* Ec=3.6 uJ and majority-carrier zero reverse-recovery charge.
.param MOS_CGD=112p
* Datasheet charging-time-equivalent Coss=456 pF includes Cgd; use Cds=456-112=344 pF here
* and retain Cgd separately so the reactive charge is not double-counted.
.param MOS_COSS=344p

* HOT supply and healthy boost plant. F2 opens between VD and VB.
Vline line 0 DC {VLINE}
Lboost line sw {LBOOST} IC={IINIT}
* C3D20065D has two common-cathode legs; the selected source ties both
* anodes in parallel.  Each diode instance approximates the per-leg source data with45pF, so the plant carries two physical current paths.
Vd_sense1 sw d_sense1 0
Dboost1 d_sense1 vd DBOOST
Vd_sense2 sw d_sense2 0
Dboost2 d_sense2 vd DBOOST
* C3D20065D is a majority-carrier SiC Schottky.  TT is deliberately zero;
* M=0 makes the 45 pF operating-point surrogate constant: its 400 V energy
* is 3.6 uJ and its 0..400 V charge is 18 nC, close to the 24 nC typical
* capacitive-charge datum without inventing a reverse-recovery tail.
.model DBOOST D(IS=1e-14 N=1.4 RS=20m CJO=45p M=0 VJ=1 TT=0 BV=650 IBV=1u)
Clocal vd 0 {CLOCAL} IC={VD_INIT}
Rlocal vd 0 450k
Cbank vb 0 2240u IC={VB_INIT}
Rbank vb 0 10meg
VfuseCtl f2ctl 0 PWL(0 5 {T_OPEN-1n} 5 {T_OPEN} 0 {T_CLOSE} 0 {T_CLOSE+1n} 5)
Sfuse vd vb f2ctl 0 SWF2
.model SWF2 SW(Ron=15m Roff=1e12 Vt=2.5 Vh=.1)

* PWM/current switch.  A level-1 MOS channel gives finite output-current
* saturation (rather than an unlimited voltage-controlled resistor): KP=4.0
* S, VTO=4 V and 1 mOhm package R each yield about50mOhm atVGS10V/ID30A and
* about 72 A channel saturation at VGS=10 V.  Coss and Miller Cgd remain
* explicit reactive paths; no current clipping or timestep masking.
Vpwm pwm 0 PULSE(0 5 {PWM_DELAY} 20n 20n {PW_ON} 10u)
.param ARM_OFFSET=20u
Varm arm 0 PWL(0 0 {T_ARM+ARM_OFFSET-20n} 0 {T_ARM+ARM_OFFSET} 5 {ARM_HOLD+ARM_OFFSET} 5 {ARM_HOLD+ARM_OFFSET+1n} 0)
Varm2 arm2 0 PWL(0 0 {T_ARM2-20n} 0 {T_ARM2} 5 {T_ARM2+500n} 0)
Vpermit permit 0 PWL(0 5 {PERMIT_DROP-1n} 5 {PERMIT_DROP} 0 {PERMIT_RETURN-1n} 0 {PERMIT_RETURN} 5)
* rails_ok is generated by the TPS3890-like supervisors in controller.inc.
* Drain is the switched boost node; source/body return through the explicit
* Kelvin sense branch.  Keeping the zero-volt source in series (rather than
* across drain/source) makes i(vg_sense) the actual channel current.
Msw sw gate sw_conduct sw_conduct STWMOS
Vg_sense sw_conduct sw_mid 0
* The explicit body-diode path carries the bounded reverse-recovery
* assumption.  The MOS bulk junction is suppressed (IS=1e-40) so it cannot
* silently duplicate that path through the Kelvin current probe.
Vbody_sense sw_mid body_sense 0
Dbod body_sense sw DBODY
.model DBODY D(IS=1e-14 N=1.2 RS=8m BV=650 IBV=1u TT=8n)
.model STWMOS NMOS (VTO=4 KP=4.0 RD=1m RS=1m L=1u W=1u IS=1e-40)
Coss sw sw_mid {MOS_COSS}
Cgd sw gate {MOS_CGD}
Cgs gate sw_mid {GATE_TAU/10}
Rsw_sense sw_mid sw_sense 1m
Vsw_sense sw_sense 0 0

* Keep named HOT interface nets in the saved trace for source/graph binding.
* aux15 and logic5 are fixed healthy inputs for energy rows; controller.inc
* derives rails_ok after its startup hold and drives the loaded gate.
Vlogic5 logic5 0 5
Vaux15 aux15 0 15
Rgnd gnd 0 1m

.include /private/tmp/temper-pkgs-1-4/zapote/power-entry/passive-reva/protection/f2-shutdown-04/plant/controller.inc
.param EN_TAU=39n

.tran {TSTEP} {TSTOP} uic
.save time v(line) v(vd) v(vb) v(dh) v(dl) v(bh) v(bl) v(fault) v(health) v(q) v(en) v(drv) v(gate_cmd) v(gate) v(pwm) v(arm) v(permit) v(rails_ok) v(f2ctl) i(lboost) v(sw) v(sw_mid) v(sw_sense) i(vline) i(vd_sense1) i(vd_sense2) i(vg_sense) i(vbody_sense)
.control
set filetype=ascii
set wr_singlescale
set wr_vecnames
run
wrdata /private/tmp/temper-pkgs-1-4/zapote/power-entry/passive-reva/protection/f2-shutdown-04/plant/traces/f2_open_50_adverse.tsv time v(line) v(vd) v(vb) v(dh) v(dl) v(bh) v(bl) v(fault) v(health) v(q) v(en) v(drv) v(gate_cmd) v(gate) v(pwm) v(arm) v(permit) v(rails_ok) v(f2ctl) i(lboost) v(sw) v(sw_mid) v(sw_sense) i(vline) i(vd_sense1) i(vd_sense2) i(vg_sense) i(vbody_sense)
meas tran peak_vd MAX v(vd)
meas tran peak_i MAX i(lboost)
write /private/tmp/temper-pkgs-1-4/zapote/power-entry/passive-reva/protection/f2-shutdown-04/plant/raw/f2_open_50_adverse.raw all
quit
.endc
.end
