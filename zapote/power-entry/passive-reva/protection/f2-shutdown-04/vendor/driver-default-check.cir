* Unmodified TI SLVMCJ6 driver, split outputs tied before common gate resistor.
.include UCC27511A_TINA_TRANS/UCC27511A.lib
Vaux aux 0 PWL(0 15 7u 15 7.01u 0 9u 0 9.01u 15 12u 15)
Vpwm pwm 0 5
Vrun run 0 PWL(0 0 1u 0 1.001u 5 3u 5 3.001u 0 5u 0 5.001u 5 6u 5 6.001u 0 12u 0)
Rbase run base 47k
Rbe base 0 100k
Qenable disable base 0 NPN_CHECK
* Conservative explicit external pull-up bounds release RC independently of internal200k.
Rdisable aux disable 10k
.model NPN_CHECK NPN(IS=1e-14 BF=100 VAF=100 CJE=20p CJC=10p TF=1n TR=50n)
Xdriver disable pwm aux 0 out out UCC27511A
Rg out gate 10
Rgs gate 0 10k
Cgate gate 0 12n
.tran 1n 12u
.control
set wr_singlescale
set wr_vecnames
run
meas tran default_off MAX v(gate) FROM=0 TO=0.9u
meas tran armed_high MIN v(gate) FROM=2u TO=2.9u
meas tran disarmed_low MAX v(gate) FROM=4u TO=4.9u
meas tran absent_aux MAX v(gate) FROM=8u TO=8.9u
meas tran returned_aux_disarmed MAX v(gate) FROM=10u TO=12u
meas tran output_disable TRIG v(disable) VAL=2.2 RISE=1 TARG v(out) VAL=13.5 FALL=1
meas tran loaded_gate_to4V TRIG v(run) VAL=2.5 FALL=1 TARG v(gate) VAL=4 FALL=1
wrdata driver-default-check.tsv v(run) v(disable) v(out) v(gate) v(aux)
quit
.endc
.end
