* Explicit temperature commands; all readings remain model outputs.
.title Diodes Inc BAV23C temperature screen via control command
.include diodes-bav23c.spice.txt
VSHUNT shunt 0 DC -0.438
RIN shunt isense 220
DCLAMP 0 isense DI_BAV23C
.control
set noaskquit
set temp=-40
op
print v(isense) @dclamp[id]
set temp=-20
op
print v(isense) @dclamp[id]
set temp=25
op
print v(isense) @dclamp[id]
set temp=85
op
print v(isense) @dclamp[id]
set temp=125
op
print v(isense) @dclamp[id]
.endc
.end
