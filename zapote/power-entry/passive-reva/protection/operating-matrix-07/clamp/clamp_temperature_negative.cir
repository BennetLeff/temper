* Temperature sensitivity screen for a -5 V shunt excursion.
.include clamp.inc
VSHUNT shunt 0 DC -5
R_ISENSE shunt isense 220
DCLAMP 0 isense BAV23C_ASSUMED_V2
.control
foreach t -20 25 85 125
  set temp = $t
  op
  print v(shunt) v(isense) @dclamp[id]
end
.endc
.end
