* PCL preservation probe: -0.438 V shunt excursion.
.include clamp.inc
VSHUNT shunt 0 DC -0.438
R_ISENSE shunt isense 220
DCLAMP 0 isense BAV23C_ASSUMED_V2
.op
.print op v(shunt) v(isense) i(R_ISENSE) i(DCLAMP)
.end
