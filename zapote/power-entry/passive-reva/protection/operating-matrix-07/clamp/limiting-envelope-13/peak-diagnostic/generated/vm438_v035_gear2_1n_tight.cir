* limiting-envelope-13 peak diagnostic: vm438_v035/gear2_1n_tight
* Same finite pulse and piecewise clamp as the parent fixture.
.param VAMP=-0.438 VF=0.350 RSH=220 RCL=1m
VSHUNT shunt 0 PULSE(0 {VAMP} 1u 10n 10n 4u 8u)
VMEAS shunt shunt_m 0
R_ISENSE shunt_m isense {RSH}
CISENSE isense 0 1n
BCLAMP 0 clamp_m I={((-V(isense)>VF) ? ((-V(isense)-VF)/RCL) : 0)}
VCLAMP clamp_m isense 0
.options method=gear maxord=2 reltol=1e-9 abstol=1e-15 vntol=1e-12
.save time v(shunt) v(shunt_m) v(isense) i(VMEAS) i(VCLAMP)
.tran 1n 8u 0 1n
.control
run
let resistor_power=(v(shunt_m)-v(isense))*i(VMEAS)
let clamp_power=-v(isense)*i(VCLAMP)
meas tran isense_flat AVG v(isense) FROM=4u TO=4.8u
meas tran resistor_i_flat AVG i(VMEAS) FROM=4u TO=4.8u
meas tran clamp_i_flat AVG i(VCLAMP) FROM=4u TO=4.8u
meas tran resistor_i_max MAX i(VMEAS) FROM=0 TO=8u
meas tran clamp_i_max MAX i(VCLAMP) FROM=0 TO=8u
meas tran resistor_energy_total INTEG resistor_power FROM=0 TO=8u
meas tran clamp_energy_total INTEG clamp_power FROM=0 TO=8u
write vm438_v035_gear2_1n_tight.raw time v(shunt) v(isense) i(VMEAS) i(VCLAMP)
quit
.endc
.end
