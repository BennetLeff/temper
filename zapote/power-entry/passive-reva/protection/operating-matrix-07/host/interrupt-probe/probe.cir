* Isolated ngspice interrupt/export probe. Never use against a production run.
V1 in 0 SIN(0 1 1k)
R1 in out 1k
C1 out 0 1u
.control
set noaskquit
set wr_singlescale
set wr_vecnames
set numdgt=17
tran 1u 20s
meas tran probe_final FIND v(out) AT=20s
resume
wrdata probe-partial.tsv time v(in) v(out)
quit
.endc
.end
