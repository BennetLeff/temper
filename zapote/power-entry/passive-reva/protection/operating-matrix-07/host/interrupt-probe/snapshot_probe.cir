* Separate stop-breakpoint snapshot probe; not an interrupt or production run.
V1 in 0 SIN(0 1 1k)
R1 in out 1k
C1 out 0 1u
.control
set noaskquit
stop when time = 0.2s
tran 1u 1s
snsave probe.snap
quit
.endc
.end
