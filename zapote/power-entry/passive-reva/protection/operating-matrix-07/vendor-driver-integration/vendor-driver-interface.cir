* UCC27511A TI transient-model integration against the matrix-07 disable path.
* The driver model is the unchanged retained file from f2-shutdown-04/vendor.
* Model pin order is INM INP VDD GND OUTH OUTL (not the KiCad pin order).
.include ../../f2-shutdown-04/vendor/UCC27511A_TINA_TRANS/UCC27511A.lib

* PWM toggles independently while RUN is high. AUX collapses while the gate is
* active, RUN then falls while AUX is absent, and AUX return must not restart
* the output until the later fresh RUN edge.
Vaux aux15 0 PWL(0 15 20u 15 20.001u 0 27u 0 27.001u 15 35u 15)
Vpwm pwm 0 PWL(0 0 1u 0 1.001u 5 5u 5 5.001u 0 8u 0 8.001u 5 35u 5)
Vrun run 0 PWL(0 0 1u 0 1.001u 5 12u 5 12.001u 0 15u 0 15.001u 5 24u 5 24.001u 0 30u 0 30.001u 5 35u 5)

* Current normal-tracked protection.inc disable interface.
Rsmallgate run smallgate 1k
Rsmallpd smallgate 0 100k
Rdisable aux15 disable 1k
Mdisable disable smallgate 0 0 DISABLE_FET
.model DISABLE_FET NMOS(VTO=1.5 KP=.1 RD=2 RS=2)
Csmallgs smallgate 0 60p
Csmallgd smallgate disable 10p
Csmallds disable 0 15p

* Current normal-tracked PWM isolation.
Rpwm pwm pwm_input 1k
Rpwmpd pwm_input 0 10k

* TI model pin order: INM, INP, VDD, GND, OUTH, OUTL.
Xdriver disable pwm_input aux15 0 outh outl UCC27511A
Rgon outh gate 10
Rgoff outl gate 10
Rgs gate 0 10k
Cgate gate 0 12n

.tran 1n 35u
.control
set numdgt=17
set wr_singlescale
set wr_vecnames
run
meas tran default_off MAX v(gate) FROM=0 TO=0.9u
meas tran pwm_enabled MIN v(gate) FROM=2u TO=4.5u
meas tran pwm_disabled MAX v(gate) FROM=6u TO=7.5u
meas tran pwm_reenabled MIN v(gate) FROM=9u TO=11.5u
* Allow the normal 0.25 us run-fall-to-gate-4 V delay to settle before checking
* the active-RUN disable plateau.
meas tran run_disabled MAX v(gate) FROM=13u TO=14.5u
meas tran aux_drop MAX v(gate) FROM=21u TO=26.5u
meas tran aux_active_high MIN v(gate) FROM=17u TO=19.5u
meas tran aux_return_disarmed MAX v(gate) FROM=28u TO=29.5u
meas tran rearmed MIN v(gate) FROM=32u TO=34.5u
wrdata vendor-driver-interface.tsv v(run) v(disable) v(outl) v(gate) v(aux15)
quit
.endc
.end
