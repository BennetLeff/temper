* 35 us matrix sequence using the unchanged TI UCC27511A transient model.
.include ../../../f2-shutdown-04/vendor/UCC27511A_TINA_TRANS/UCC27511A.lib
Vaux aux15 0 PWL(0 15 20u 15 20.001u 0 27u 0 27.001u 15 35u 15)
Vpwm pwm 0 PWL(0 0 1u 0 1.001u 5 5u 5 5.001u 0 8u 0 8.001u 5 35u 5)
Vrun run 0 PWL(0 0 1u 0 1.001u 5 12u 5 12.001u 0 15u 0 15.001u 5 24u 5 24.001u 0 30u 0 30.001u 5 35u 5)
Rsmallgate run smallgate 1k
Rsmallpd smallgate 0 100k
Rdisable aux15 disable 1k
Mdisable disable smallgate 0 0 DISABLE_FET
.model DISABLE_FET NMOS(VTO=1.5 KP=.1 RD=2 RS=2)
Csmallgs smallgate 0 60p
Csmallgd smallgate disable 10p
Csmallds disable 0 15p
Rpwm pwm pwm_input 1k
Rpwmpd pwm_input 0 10k
Xdriver disable pwm_input aux15 0 outh outl UCC27511A
Rgon outh gate 10
Rgoff outl gate 10
Rgs gate 0 10k
Cgate gate 0 12n
.tran 1n 35u
.control
set numdgt=17
set wr_singlescale
set wr_vecnames
run
wrdata vendor-sequence.tsv v(run) v(disable) v(pwm_input) v(aux15) v(outh) v(outl) v(gate)
quit
.endc
.end
