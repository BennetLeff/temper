* Unknown-state PWM DAC safety probe; standalone host-model fixture.
Vmid raw 0 2.5
Aadc [raw] [data] UADC
Aold [data] [hold_old] UDAC_BAD
Abad [data] [hold_bad] UDAC_BAD
Asafe [data] [hold_safe] UDAC_SAFE
.model UADC adc_bridge(in_low=2 in_high=3)
.model UDAC_BAD dac_bridge(out_low=0 out_high=5 out_undef=2.5)
.model UDAC_SAFE dac_bridge(out_low=0 out_high=5 out_undef=0)
Bgate_old gate_old 0 V=(V(hold_old)>2.5) ? 15 : 0
Bgate_bad gate_bad 0 V=3*V(hold_bad)
Bgate_safe gate_safe 0 V=3*V(hold_safe)
Rold gate_old 0 1meg
Rbad gate_bad 0 1meg
Rsafe gate_safe 0 1meg
.options method=gear reltol=1e-6 abstol=1e-12 vntol=1e-9
.save time v(raw) v(data) v(hold_old) v(hold_bad) v(hold_safe) v(gate_old) v(gate_bad) v(gate_safe)
.tran 1n 10n 0 1n uic
.control
set wr_singlescale
set wr_vecnames
set numdgt=17
run
print v(data) v(hold_old) v(hold_bad) v(hold_safe) v(gate_old) v(gate_bad) v(gate_safe)
wrdata unknown-analog.tsv v(raw) v(hold_old) v(hold_bad) v(hold_safe) v(gate_old) v(gate_bad) v(gate_safe)
quit
.endc
.end
