* 1 ns PWM input edges, fixed healthy AUX and active-low disable input.
.include authored_logic_hysteretic.inc
Vaux aux15 0 15
Vdisable disable 0 0
Vpwm pwm_input 0 PWL(0 0 2u 0 2.9995u 0 3u 5 5u 5 5.0005u 5 5.001u 0 8u 0)
Xdriver disable pwm_input aux15 0 driver_out AUTH_UCC27511A_H
Rgate driver_out gate 10
Rgs gate 0 10k
Cgate gate 0 12n
.tran 1n 8u
.control
set numdgt=17
set wr_singlescale
set wr_vecnames
run
wrdata authored-fast.tsv v(pwm_input) v(driver_out) v(gate) v(aux15) v(disable) v(xdriver.pwm_state) v(xdriver.inm_state) v(xdriver.aux_state) v(xdriver.driver_req)
quit
.endc
.end
