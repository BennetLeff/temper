* synthetic native42 transport fixture; never send to ngspice
.include fixture.inc
