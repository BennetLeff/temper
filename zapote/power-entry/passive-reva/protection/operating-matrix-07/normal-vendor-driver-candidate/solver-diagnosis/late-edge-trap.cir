* Full-plant-time translated edge replay. The source values and edge timing
* match the tail immediately before the 0.0973456252139008882 s stall.
.include ../vendor/UCC27511A.lib
Vaux aux15 0 15
Vdisable disable 0 0.104086117
Vpwm pwm 0 PWL(0 13.5826772 0.09734561255392814 13.5826772 0.09734561355392814 0 0.1 0)
Vsw sw 0 0.0768
Xdriver disable pwm aux15 0 outh outl UCC27511A
Rgon outh gate 10
Rgoff outl gate 10
Rgs gate 0 10k
Cgate gate 0 12n
Cgd gate sw 112p
Cds sw 0 344p
.options method=trap reltol=2e-4 abstol=1e-10 vntol=1e-7
.tran 500n 0.1 0 500n
.control
set ngbehavior=ps
set numdgt=17
set wr_singlescale
set wr_vecnames
run
wrdata late-edge-trap.tsv v(pwm) v(outh) v(outl) v(gate) v(sw)
quit
.endc
.end
