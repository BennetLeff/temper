* Revision 20 exploratory LTspice run from the revision 19 clamp graph.
* Model: LT4363-1 and FDB33N25 from ADI LTspice 26.0.2 library.
* D1 uses the bundled 1N4148 model as a surrogate for 1N4148W.
* A 130 ohm resistive load and 0.5 ohm source are declared test inputs,
* not the converter startup model or qualified source envelope.
Vsrc SOURCE 0 PWL(0 0 1m 0 1.01m 15 5 15)
Rsrc SOURCE AUX_RAW 0.5
Rshdn AUX_RAW SERVICE_RESET_N 1
R1 SNS AUX_PROTECTED 0.22
R2 AUX_PROTECTED FB 59k
R3 FB 0 4.99k
R4 AUX_RAW UV 91k
R5 UV 0 10k
R6 GATE_DRV Q_GATE 10
R7 GATE_DRV CG 100
C1 AUX_RAW 0 100n
C2 TMR 0 100n
C3 CG 0 1.5u
C4 AUX_PROTECTED 0 330u
D1 GATE_DRV CG 1N4148
M1 AUX_RAW Q_GATE SNS SNS FDB33N25
Rload AUX_PROTECTED 0 130
* Investigative output short path: 0.5 ohm switch for 50 ms after settling.
Vctrl CTRL 0 PWL(0 0 4 0 4.00001 1 4.05001 1 4.05002 0 5 0)
Sshort AUX_PROTECTED 0 CTRL 0 SHORTSW
.model SHORTSW SW(Ron=0.5 Roff=1e9 Vt=0.5 Vh=0.05)
XU1 FB AUX_PROTECTED SNS GATE_DRV AUX_RAW SERVICE_RESET_N UV 0 FLT ENOUT TMR LT4363-1
.lib C:\users\crossover\AppData\Local\LTspice\lib\cmp\standard.dio
.lib C:\users\crossover\AppData\Local\LTspice\lib\cmp\standard.mos
.lib LT4363-1.sub
.tran 0 5 0 20u startup
.meas TRAN output_at_4s FIND V(AUX_PROTECTED) AT 4
.meas TRAN output_at_4010ms FIND V(AUX_PROTECTED) AT 4.01
.meas TRAN output_at_4050ms FIND V(AUX_PROTECTED) AT 4.05
.meas TRAN output_at_4200ms FIND V(AUX_PROTECTED) AT 4.2
.meas TRAN output_at_5s FIND V(AUX_PROTECTED) AT 5
.meas TRAN fet_current_peak MAX Id(M1) FROM 4 TO 4.06
.meas TRAN fet_current_at_4050ms FIND Id(M1) AT 4.05
.meas TRAN fet_current_at_5s FIND Id(M1) AT 5
.meas TRAN fet_power_peak MAX (V(AUX_RAW,SNS)*Id(M1)) FROM 4 TO 4.06
.meas TRAN fet_energy INTEG (V(AUX_RAW,SNS)*Id(M1)) FROM 4 TO 4.06
.meas TRAN vds_peak MAX V(AUX_RAW,SNS) FROM 4 TO 4.06
.meas TRAN tmr_peak MAX V(TMR) FROM 4 TO 5
.meas TRAN tmr_at_5s FIND V(TMR) AT 5
.meas TRAN gate_at_5s FIND V(Q_GATE) AT 5
.backanno
.end
