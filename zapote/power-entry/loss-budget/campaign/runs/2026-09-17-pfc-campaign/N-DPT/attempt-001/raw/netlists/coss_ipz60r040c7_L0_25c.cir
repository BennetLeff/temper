* ============================================================
* Coss(v) and Qoss/Eoss via small-signal AC admittance at DC bias.
* DUT: IPZ60R040C7_L0 (Infineon CoolMOS C7 vendor model, Level-0).  Vgs = 0.
* The DC drain ramp method could not be run (ngspice timestep collapse at
* the vendor model's internal gate node); the AC method is the standard
* datasheet Coss(v) definition.
* ============================================================
.param TEMP=25
.temp 25
.include "../models/infineon_c7_600v_spice_ngspice.lib"

Vbias d 0 DC 0 AC 1
Xdut d g 0 IPZ60R040C7_L0
Vg g 0 0

.options itl1=300 itl6=100 gmin=1e-9 reltol=1e-3 abstol=1e-9 vntol=1e-4

.control
foreach vb 0 2 4 6 8 10 12 15 18 20 25 30 40 50 60 80 100 120 150 180 200 250 300 350 400
  alter Vbias dc = $vb
  op
  ac lin 1 100k 100k
  let coss = imag(-i(vbias))/(2*3.141592653589793*100k)
  echo BIAS $vb
  print coss
end
.endc
.end
