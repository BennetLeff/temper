* independent ngspice reproduction of revised Python nominal healthy 194.1 ohm row
VBIAS bias 0 2
VREFSRC refsrc 0 1.2486910002
RREF bias forcep_i 430
RFPATH forcep_i sensorp 1
RRTD sensorp sensorn 194.1
RFNATH sensorn forcen_i 1
RRETURN forcen_i 0 1m
RSPATH sensorp sensep 1
RSNATH sensorn sensem 1
RDIAGP bias sensep 1Meg
RDIAGN bias sensem 1Meg
RWINP sensep windowp 100k
RLOWTOPX refsrc lowth 61900
RLOWBOTX lowth sensem 10000
RHIGHTOPX refsrc highth 5900
RHIGHBOTX highth 0 10000
.op
.control
run
print v(sensep) v(windowp) v(sensem) v(lowth) v(highth)
.endc
.end
