* healthy initial point for exact short transient
VBIAS bias 0 2.06
VREFSRC refsrc 0 1.25
RREF bias forcep_i 430
RFPATH forcep_i sensorp 1
RRTD sensorp sensorn 100
RFNATH sensorn forcen_i 1
RRETURN forcen_i 0 1m
RSPATH sensorp sensep 1
RSNATH sensorn sensem 1
RDIAGP bias sensep 1Meg
RDIAGN bias sensem 1Meg
RWINP sensep windowp 100k
RLOWTOPX refsrc lowth 61900
RLOWBOTX lowth sensem 10000
RHIGHTOPX refsrc highth 5900
RHIGHBOTX highth 0 10000
CDIFF sensep sensem 1.1n
CGP sensep 0 100p
CGN sensem 0 100p
.op
.control
run
print op v(sensep) v(sensem)
.endc
.end
