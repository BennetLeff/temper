* D19 periodic source scenario; two identical leg-A matrices, series RLC load.
* This is not a measured full-bridge waveform or a tank-control operating point.
.include IFX_CFD7_650V.lib
.include /Users/bennet/.codex/worktrees/ps-r17-d22/temper/zapote/power-stage-120v/validation-plan/sim-kit/common/options.inc
.options itl4=100000
.options method=trap maxord=2
.param RTANK=2
.param VBUS=170 IL=37 FREQ=35000 T1=2u DT=443n TRMAX=2n CYCLES=4
.param LP1=26n LP2=26n LP3=20n LP4=20n K12=0.6 K13=0.1 K14=0.15 K23=0.1 K24=0.15 K34=0
.param LESL=10n LSHUNT=2n LBULK=21.519n RG=3.9 ROL=0.55 ROH=5 VDRV=15 CSNUB=1n
.param C38=0.1u C39=0.1u CBULK=5.4u

.include params.inc
Vbus src 0 {VBUS}
Rsrc src bulk 10m
Cbulk bulk 0 {CBULK}
Lbulk bulk bus {LBULK}
XLA bus swa leg DIR=0
XLB bus swb leg DIR=1
Rtank swa tank1 {RTANK}
Ltank tank1 tank2 70u
Ctank tank2 swb 0.54u
.subckt leg bus sw params: DIR=0
.param GL0={VDRV*(1-DIR)} GL1={VDRV*DIR}
.param GH0={VDRV*DIR} GH1={VDRV*(1-DIR)}
.param TLS={T1+DIR*DT} THS={T1+(1-DIR)*DT}
.param ILOAD_SIGNED={IL*(1-2*DIR)}

L_P1 bus c38a {LP1}
Lesl38 c38a c38b {LESL}
Rc38 c38b c38c 5m
Cc38 c38c 0 {C38}
L_P2 bus c39a {LP2}
Lesl39 c39a c39b {LESL}
Rc39 c39b c39c 5m
Cc39 c39c 0 {C39}

* ---- power path: bus -> HS -> sw -> LS -> shunt -> 0 (board L is in L_P1/L_P2)
Vfeed bus inverter 0
XQH inverter g_hs sw IPW65R018CFD7_L1
Vids sw d_ls 0
XQL d_ls g_ls s_ls IPW65R018CFD7_L1
Lshunt s_ls shunt {LSHUNT}
Rshunt shunt 0 1m
Csnh inverter sw {CSNUB}
Csnl d_ls s_ls {CSNUB}

* ---- drivers: output-resistance approximation (round 3), then the gate
* resistor, then the board gate-loop inductor (first node at the gate)
Vgl_cmd gl_cmd s_ls PULSE({GL0} {GL1} {TLS} 5n 5n {0.5/FREQ+(1-2*DIR)*DT-5n} {1/FREQ})
Bgl gdl s_ls I={v(gdl,s_ls)*(1-v(gl_cmd,s_ls)/VDRV)/ROL+(v(gdl,s_ls)-VDRV)*v(gl_cmd,s_ls)/(VDRV*ROH)}
Rgl gdl gdl3 {RG}
L_P4 g_ls gdl3 {LP4}
Rholdl g_ls s_ls 10k
Vgh_cmd gh_cmd sw PULSE({GH0} {GH1} {THS} 5n 5n {0.5/FREQ+(2*DIR-1)*DT-5n} {1/FREQ})
Bgh gdh sw I={v(gdh,sw)*(1-v(gh_cmd,sw)/VDRV)/ROL+(v(gdh,sw)-VDRV)*v(gh_cmd,sw)/(VDRV*ROH)}
Rgh gdh gdh3 {RG}
L_P3 g_hs gdh3 {LP3}
Rholdh g_hs sw 10k

* ---- FEM couplings
K12 L_P1 L_P2 {K12}
K13 L_P1 L_P3 {K13}
K14 L_P1 L_P4 {K14}
K23 L_P2 L_P3 {K23}
K24 L_P2 L_P4 {K24}
K34 L_P3 L_P4 {K34}

.ends leg
.tran {TRMAX} {T1+CYCLES/FREQ} {T1+(CYCLES-2)/FREQ} {TRMAX}
.save v(swa) v(swb) v(bus) i(v.xla.vfeed) i(v.xlb.vfeed) i(vbus)
.meas tran sw_max MAX v(swa) from={T1+(CYCLES-1)/FREQ} to={T1+CYCLES/FREQ}
.end
