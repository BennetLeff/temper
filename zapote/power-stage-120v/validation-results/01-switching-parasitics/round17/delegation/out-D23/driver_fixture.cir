* D23: unmodified TI SLUM881 UCC21550B-Q1 proxy characterization
.include ../../vendor/ucc21550-q1.lib
.param RDT=50k GAP=200n CL=1.8n VDD=12 DT_DISABLE=0
.include params.inc
Vcc vcc 0 3.3
Vdda vdda 0 {VDD}
Vddb vddb 0 {VDD}
* DC operating point avoids measuring supply startup; transition after 20us.
Va ina 0 PULSE(3.3 0 20u 1n 1n 2u 4u)
Vb inb 0 PULSE(0 3.3 {20u+GAP} 1n 1n {2u-2*GAP} 4u)
* DT_DISABLE=1 drives DT to VCCI through low impedance, per datasheet.
Rdt dt 0 {RDT}
Rdisable dt vcc {if(DT_DISABLE,0.001,1e12)}
Xdrv ina inb vcc 0 0 dt vdda outa 0 vddb outb 0 UCC21550-Q1
Ca outa 0 {CL}
Cb outb 0 {CL}
.options method=gear reltol=1e-4 abstol=1e-10 vntol=1e-7 itl1=500 itl4=100000
.tran 0.1n 24u 19.9u 0.1n
.meas tran t_end FIND time AT=24u
.meas tran tf TRIG v(outa) VAL={0.9*VDD} FALL=1 TARG v(outa) VAL={0.1*VDD} FALL=1
.meas tran tr TRIG v(outb) VAL={0.2*VDD} RISE=1 TARG v(outb) VAL={0.8*VDD} RISE=1
.meas tran tphl TRIG v(ina) VAL=1.0 FALL=1 TARG v(outa) VAL={0.9*VDD} FALL=1
.meas tran tplh TRIG v(inb) VAL=2.0 RISE=1 TARG v(outb) VAL={0.1*VDD} RISE=1
.meas tran deadtime TRIG v(outa) VAL={0.9*VDD} FALL=1 TARG v(outb) VAL={0.1*VDD} RISE=1
.meas tran dt_voltage FIND v(dt) AT=19.9u
.end
