.SUBCKT R46KN4100JHP1M 1 6
*Temp = 25?C, Bias = 0VDC, Center Frequency = 10000 Hz
*KEMET Model RLC Cerm
R1 3 4 0.026660026982426643
R2 2 5 2.6660027503967285
R3 1 6 70000001024
L1 1 2 6.424405007976475E-10
L2 2 3 1.2206369515155301E-08
C1 4 6 1.0000040902014007E-06
C2 5 6 0
.ENDS
