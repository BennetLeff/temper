* Task 02: tank-CT detector front end (native-13 values), analog timing.
* Tank current is a sine at FREQ whose amplitude grows linearly (fault ramp).
* Run: python3 ../common/run_ngspice.py ct_frontend.cir FREQ=35k I0=37 SLOPE=3e6
*
* Measures (absolute times; sweep.py subtracts them), relative to the instant
* the primary current first reaches ITRIP:
*   t_pos_trip  comparator U10 output rising through 1.65 V
*   t_or        fault OR output rising through 1.65 V (add the downstream
*               interlock + PERMIT + driver delays from detector_chain.py)
* and the zero-cross comparator's lag behind the current zero crossing.

.include ../common/options.inc
.param FREQ=35k I0=37 SLOPE=3e6 ITRIP=55.17 VCC=3.3 VOS=0 TPD=55n TSTOP=200u
.include params.inc

* ---- primary current: (I0 + SLOPE*t) * sin(2 pi FREQ t), capped at 150 A
Bip ipri 0 V={min(I0+SLOPE*time,150)*sin(6.283185307*FREQ*time)}
* ---- CT: 1:100, magnetizing 3.2 mH, secondary DCR 1.5 ohm (CST3015-100ED)
* Floating secondary: current leaves CT_S2 and enters ctx (never through ground).
Bsec ct_s2 ctx I={v(ipri)/100}
Lmag ctx ct_s2 3.2m
Rdcr ctx ct_s1 1.5
* ---- burden and its capacitor (R39, C42)
Rbur ct_s1 ct_s2 1.5
Cbur ct_s1 ct_s2 100n
* ---- bias midpoint (R40, R41, C43)
Vcc vcc 0 {VCC}
Rbt vcc ct_s2 1k
Rbb ct_s2 0 1k
Cbias ct_s2 0 100n
* ---- series input and clamps (R42, D4/D5 BAS116H; generic small-signal model)
Rser ct_s1 sense 1k
D4 sense vcc DCLAMP
D5 0 sense DCLAMP
.model DCLAMP D(IS=2.5n N=1.8 RS=0.6 CJO=1.5p BV=85)
* ---- references (R43/R44 = 3.32k/10k, R45/R46 = 10k/3.32k)
Rht vcc ref_hi 3.32k
Rhb ref_hi 0 10k
Rlt vcc ref_lo 10k
Rlb ref_lo 0 3.32k
* ---- comparators: ideal decision with offset, then pure delay TPD (TLV3201)
Bpos pos_i 0 V={VCC*(0.5+0.5*tanh((v(sense)-v(ref_hi)-VOS)/1m))}
Tpos pos_i 0 pos_d 0 Z0=50 TD={TPD}
Rpos pos_d 0 50
Bneg neg_i 0 V={VCC*(0.5+0.5*tanh((v(ref_lo)-v(sense)-VOS)/1m))}
Tneg neg_i 0 neg_d 0 Z0=50 TD={TPD}
Rneg neg_d 0 50
Bzc zc_i 0 V={VCC*(0.5+0.5*tanh((v(sense)-v(ct_s2)-VOS)/1m))}
Tzc zc_i 0 zc_d 0 Z0=50 TD={TPD}
Rzc zc_d 0 50
* ---- fault OR (U13), 4.5 ns max
Bor or_i 0 V={max(v(pos_d),v(neg_d))}
Tor or_i 0 or_d 0 Z0=50 TD=4.5n
Ror or_d 0 50

.tran 5n {TSTOP} 0 5n

.meas tran t_ip_trip WHEN v(ipri)={ITRIP} RISE=1
.meas tran t_pos_trip WHEN v(pos_d)={VCC/2} RISE=1
.meas tran t_or WHEN v(or_d)={VCC/2} RISE=1
.meas tran t_ip_zero WHEN v(ipri)=0 RISE=3
.meas tran t_zc WHEN v(zc_d)={VCC/2} RISE=3
.meas tran sense_max MAX v(sense)
.end
