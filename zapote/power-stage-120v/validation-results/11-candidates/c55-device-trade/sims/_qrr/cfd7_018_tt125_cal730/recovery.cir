* Table 8 clamped-inductive commutation; ideal constant-current load limit.
.include IFX_CFD7_650V.lib
.SUBCKT cool_tech_w3_tt dd g s Tj t1 PARAMS: a=1 dVth=0 dR=0 Inn=1 Unn=1 Rmax=1
+gmin=1 Rs=1 Rdp=1 heat=0
.PARAM  fpar42=298
.PARAM  fpar1=4.834
.PARAM  fpar2=0.00547
.PARAM  fpar3=-0.002
.PARAM  fpar4=19.1
.PARAM  fpar5={0.965*0.82}
.PARAM  fpar6=3.06
.PARAM  fpar7=0.339
.PARAM  MOS_b0_a_ref=35.81
.PARAM  MOS_b0_exp=0.1
.PARAM  fpar8=4.8745
.PARAM  fpar9=1.163575
.PARAM  fpar10=5.48
.PARAM  fpar11=0.905
.PARAM  fpar12=2.416
.PARAM  fpar13=0.314
.PARAM  fpar14=-21.85
.PARAM  fpar15=715
.PARAM  fpar16=0.715
.PARAM  fpar18={0.2757*0.85}
.PARAM  fpar19={-25.9158*0.95}
.PARAM  fpar20=125e-9
.PARAM  fpar21=1.1663
.PARAM  fpar22=0.228
.PARAM  fpar23=1.47e-15
.PARAM  CAP_CdgN1A=1.347e-10
.PARAM  CAP_CdgN1P=1e-10
.PARAM  fpar26=5.14e-12
.PARAM  fpar27=1.6e-15
.PARAM  fpar28=1e-16
.PARAM  fpar29=1.15e-11
.PARAM  fpar30=4e-13
.PARAM  fpar31=9.99e-14
.PARAM  fpar32=90
.PARAM  fpar33=1.7e-12
.PARAM  fpar34=19e-013
.PARAM  fpar35=5.136e-10
.PARAM  fpar36=1.0414835e-07
.PARAM  fpar37=3.67454e-09
.PARAM  fpar38=1.995e-10
.PARAM  fpar39=1e-12
.PARAM  fpar17=0.0
.PARAM	fpar40=85.8u
.PARAM  fpar41=273
.PARAM  dRdi={fpar18/a}
.PARAM  Cdio={fpar23*a}
.PARAM  Cdg1={CAP_CdgN1A*a+CAP_CdgN1P*SQRT(a)}
.PARAM  Cdg2={fpar26*a}
.PARAM  CdgV1={fpar27*a}
.PARAM  CdgV2={(fpar31*a+fpar28)}
.PARAM  Cds0={fpar33*a+fpar34*SQRT(a)}
.PARAM  Cds1={a*fpar35}
.PARAM  Cgs0={fpar38*a+fpar39*(SQRT(a))}
.PARAM  MOS_b0_a={fpar8*(MOS_b0_a_ref/a)**MOS_b0_exp}
.PARAM  Vmin=3.4   Vmax=5.4
.PARAM  Vth={fpar1+(Vmax-fpar1)*limit(dVth,0,1)-(Vmin-fpar1)*limit(dVth,-1,0)}
.PARAM  r0={MOS_b0_a*((fpar41/fpar42)**fpar9)*a}
.PARAM  r1={(Unn-Inn*Rs-fpar1)*r0}
.PARAM  r2={(fpar17*SQRT(0.4)-fpar11)*Inn*r0}
.PARAM  Rlim={(r1+2*r2*Rmax-SQRT(r1**2+4*r2))/(2*r2)}
.PARAM  dRd={fpar5/a+if(dVth==0,limit(dR,0,1)*max(Rlim-fpar5/a-Rs-Rdp,0),0)}
.PARAM  CAP_eedg=-0.556
.PARAM  x0={(fpar29-fpar26)/fpar30}  x1={fpar29/fpar30} dx={x1-x0}
.FUNC 	QCdg1(x) {Cdg2*min(x,x1)+CdgV2*max(x-x1,0)+CdgV1/2*max(0, x-fpar32)**2+(Cdg2-CdgV2)*((limit(x,x0,x1)-x0)**3/(dx*dx)*((limit(x,x0,x1)-x0)/(2*dx)-1))}
.PARAM  Eds1={-6000}	Eds2={-320}	Eds3={-200}	eeds1={-0.1667}	eeds2={-6.25m}  eeds3={-0.05}
.PARAM 	a0={(fpar36-fpar35)/fpar37} a1={fpar36/fpar37} da={a1-a0}
.FUNC 	QCds1(x) {Cds1*min(x,a1)+Cds1*((limit(x,a0,a1)-a0)**3/(da*da)*((limit(x,a0,a1)-a0)/(2*da)-1))}
E_Edg1     d1     ox  VALUE {if(V(d1,g)>0,V(d1,g)-(exp(CAP_eedg*max(V(d1,g),0))-1)/CAP_eedg,0)}
C_Cdg1     ox      g  {Cdg1}
E_Edg2     d1    ox2  VALUE {V(d1,g)-QCdg1(V(d1,g))/Cdg2}
C_Cdg2    ox2      g  {Cdg2}
C_Cds0     d1      s  {Cds0}
E_Eds1     d1  edep1  VALUE {if(V(d1,s)>0,V(d1,s)-Eds1*(exp(eeds1*max(V(d1,s),0))-1)-Eds2*(exp(eeds2*max(V(d1,s),0))-1)-Eds3*(exp(eeds3*max(V(d1,s),0))-1),0)}
C_Cds1  edep1      s  {Cds0}
E_Eds2     d1  edep2  VALUE {V(d1,s)-QCds1(V(d1,s))/Cds1}
C_Cds2  edep2      s  {Cds1}
C_Cgs       g      s  {Cgs0}
.FUNC I0(Uee,p,pp,z1,cc)  {if(Uee>pp,(Uee-cc*z1)*z1,p*(pp-p)/cc*exp((Uee-pp)/p))}
.FUNC Ig(Uds,T,p,Uee,cc)  {MOS_b0_a*(fpar41/T)**fpar9*I0(Uee,p,min(2*p,p+cc*Uds),min(Uds,Uee/(2*cc)),cc)}
.FUNC J(d,g,T,da,s)
+ {a*(s*(Ig(da,T,fpar10*fpar40*T,g-Vth+fpar2*(T-fpar42),fpar11)+1*exp(min(fpar14+(d-fpar15-fpar16*(T-fpar42))/fpar13,25))))}
G_chan    d    s  VALUE={J(V(d,s),V(g,s),fpar41+limit(V(Tj),-200,499),(SQRT(1+4*fpar12*abs(V(d,s)))-1)/2/fpar12,sgn(V(d,s)))}
V_Ichannel d1 d 0
.FUNC Rd0(T)  {(fpar7*dRd+(1-fpar7)*dRd*(T/fpar42)**fpar6)}
.FUNC CF(T,Iepi) {(fpar4**2)/max(1,fpar4**2-(Rd0(T)*Iepi)**limit(2+fpar3*(T-fpar42),1.2,3))}
V_Iepi     dd d2 0
G_G_Rd     d2 d1 VALUE {V(d2,d1)/(Rd0(fpar41+LIMIT(V(t1),-200,999))*CF(fpar41+LIMIT(V(t1),-200,999),abs(I(V_Iepi))))}
Dbody s dio dbody
.model dbody D (BV={fpar15*10}, CJO ={Cdio}, TT={fpar20}, IS ={a*exp(fpar19)} m={0.3} RS={dRdi/100} N={fpar21} )
G_Rdio   dio2   dd  VALUE={V(dio2,dd)/(dRdi*((limit(V(Tj),-200,999)+fpar41)/fpar42)**fpar22)}
V_sense2 dio2   dio  0
R_R_ERd_g  d2 d1  10k
R1        g    s    1G
Rd01      d    s    500Meg
Rd02     d2    s    500Meg
Rd03     dio   s    500Meg
G_G_Ptot_channel 0 Tj VALUE {heat*LIMIT(V(d,s)*I(V_Ichannel),0,100k) }
G_G_Ptot_Epi     0 t1 VALUE {heat*(LIMIT(V(dd,d1)*I(V_Iepi),0,100k)+LIMIT(V(dd,s)*I(V_sense2),0,100k))}
.ENDS
.SUBCKT DUT_TT drain gate source PARAMS: dVth=0 dRdson=0
.PARAM Rs=3.42E-04    Rg=2.7    Rdp=7.44E-05          Ls=2.82E-09        Ld=1.88E-09
.PARAM Lg=8.32E-09    act=58.23        Inn={1.0*58.23}  Unn=10.0       Rmax=18m
X1  dd g s Tj Tj cool_tech_w3_tt PARAMS: a={act} dVth={dVth} dR={dRdson} Inn={Inn} Unn={Unn}
                                      +Rmax={Rmax} Rs={Rs} Rdp={Rdp} heat=0
L_Ld         drain  ldrd    {Ld}
R_Ld         drain  ldrd    10
R_Rd         dd     ldrd    {Rdp}
L_Ls         source lsrs  {Ls}
R_Ls         source lsrs  10
R_Rs         s      lsrs  {Rs}
L_Lg         gate   lgrg  {Lg}
R_Lg         gate   lgrg  10
R_Rg         lgrg   g     {Rg}
E1    Tj     w      VALUE={TEMP}
R1    w      0      1u
.ENDS
.include /Users/bennet/Desktop/temper/worktrees/ps-integrate/zapote/power-stage-120v/validation-plan/sim-kit/common/options.inc
.param RG=100 TJ=25 STEP=0.2n IFWD=58.2
.include params.inc
.temp {TJ}
Vbus bus 0 400
XQH bus gh sw DUT_TT
Vprobe sw drain 0
XQD drain gd 0 DUT_TT
* Equal external gate resistors, as datasheet Table 8.
Roff gd 0 {RG}
Vcmd cmd sw PULSE(0 13 2u 5n 5n 20u 40u)
Ron cmd gh {RG}
Iload sw 0 PWL(0 0 1u {IFWD})
.tran {STEP} 12u 0 {STEP}
.save v(sw) v(xqd.dd) v(xqd.s) v(xqd.g) i(vprobe) i(v.xqd.x1.v_sense2)
.meas tran peak MAX i(vprobe) from=2u to=12u
.end
