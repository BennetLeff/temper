* Table 8 clamped-inductive commutation; ideal constant-current load limit.
.include IFX_CFD7_650V.lib
.SUBCKT cool_C8_650_var dd g s Tj t1 PARAMS: a=1 dVth=0 dR=0 Inn=1 Unn=1 Rmax=1
+gmin=1 Rs=1 Rdp=1 heat=0
.PARAM  fpar39=298
.PARAM  fpar1={4.95/(tanh(0.16*(a+9.5)))}
.PARAM  fpar2=0.0047
.PARAM  fpar3=-0.0018
.PARAM  fpar4=12.8
.PARAM  fpar5={0.375*1.02}
.PARAM  fpar6=3.2
.PARAM  fpar7=0.38
.PARAM  fpar8=7.5
.PARAM  fpar9=1.38
.PARAM  fpar10=6.6
.PARAM  fpar11=1.1
.PARAM  fpar12={0.8*6.5}
.PARAM  fpar13=0.295
.PARAM  fpar14=-23
.PARAM  fpar15=715
.PARAM  fpar16=0.715
.PARAM  fpar17={0.19*0.68}
.PARAM  fpar18=1.692e-10
.PARAM  fpar19=150e-9
.PARAM  fpar20=1.25
.PARAM  fpar21=0.19
.PARAM  fpar22=1.47e-012
.PARAM  CAP_CdgN1A=2.25e-010
.PARAM  CAP_CdgN1P=20e-12
.PARAM  fpar24=1e-011
.PARAM  fpar25={1.2*2e-015}
.PARAM  fpar26=1.9e-012
.PARAM  fpar27=7.708e-012
.PARAM  fpar28=2.2e-013
.PARAM  fpar29=0.8e-013
.PARAM  fpar30={1.7*90}
.PARAM  CAP_CdsN0A=1.8e-012
.PARAM  CAP_CdsN0P=2e-013
.PARAM  fpar32=8e-010
.PARAM  fpar33=7.0e-008
.PARAM  fpar34=2.5e-009
.PARAM  fpar35=2e-011
.PARAM  fpar36={1.1*2.5e-010}
.PARAM  fpar40=0.0
.PARAM	fpar37=85.8u
.PARAM  fpar38=273
.PARAM  dRdi={fpar17/a}
.PARAM  Cdio={fpar22*a}
.PARAM  Cdg1={CAP_CdgN1A*a+CAP_CdgN1P*SQRT(a)}
.PARAM  Cdg2={fpar24*a}
.PARAM  CdgV1={fpar25*a}
.PARAM  CdgV2={(fpar29*a+fpar26)}
.PARAM  Cds0={CAP_CdsN0A*a+CAP_CdsN0P*4*(SQRT(a))}
.PARAM  Cds1={a*fpar32}
.PARAM  Cgs0={fpar36*a+fpar35*(SQRT(a))}
.PARAM  Vmin=3.4   Vmax=5.4
.PARAM  Vth={fpar1+(Vmax-fpar1)*limit(dVth,0,1)-(Vmin-fpar1)*limit(dVth,-1,0)}
.PARAM  r0={fpar8*((fpar38/fpar39)**fpar9)*a}
.PARAM  r1={(Unn-Inn*Rs-fpar1)*r0}
.PARAM  r2={(fpar40*SQRT(0.4)-fpar11)*Inn*r0}
.PARAM  Rlim={(r1+2*r2*Rmax-SQRT(r1**2+4*r2))/(2*r2)}
.PARAM  dRd={fpar5/a+if(dVth==0,limit(dR,0,1)*max(Rlim-fpar5/a-Rs-Rdp,0),0)}
.PARAM  CAP_eedg=-0.556
.PARAM  x0={(fpar27-fpar24)/fpar28}  x1={fpar27/fpar28} dx={x1-x0}
.FUNC 	QCdg1(x) {Cdg2*min(x,x1)+CdgV2*max(x-x1,0)+CdgV1/2*max(0, x-fpar30)**2+(Cdg2-CdgV2)*((limit(x,x0,x1)-x0)**3/(dx*dx)*((limit(x,x0,x1)-x0)/(2*dx)-1))}
.PARAM  Eds1={-6000}	Eds2={-320}	Eds3={-200}	eeds1={-0.1667}	eeds2={-6.25m}  eeds3={-0.05}
.PARAM 	a0={(fpar33-fpar32)/fpar34} a1={fpar33/fpar34} da={a1-a0}
.FUNC 	QCds1(x) {Cds1*min(x,a1)+Cds1*((limit(x,a0,a1)-a0)**3/(da*da)*((limit(x,a0,a1)-a0)/(2*da)-1))}
E_Edg1     d1     ox  VALUE {if(V(d1,g)>0,V(d1,g)-(exp(CAP_eedg*max(V(d1,g),0))-1)/CAP_eedg,0)}
C_Cdg1     ox      g  {Cdg1}
E_Edg2     d1    ox2  VALUE {V(d1,g)-QCdg1(V(d1,g))/Cdg2}
C_Cdg2    ox2      g  {Cdg2}
C_Cds0     d1      s  {Cds0}
E_Eds1     d1  edep1  VALUE {if(V(d1,s)>0,V(d1,s)-Eds1*(exp(eeds1*max(V(d1,s),0))-1)-Eds2*(exp(eeds2*max(V(d1,s),0))-1)-Eds3*(exp(eeds3*max(V(d1,s),0))-1),0)}
C_Cds1  edep1      s  {Cds0}
E_Eds2     d1  edep2  VALUE {V(d1,s)-QCds1(V(d1,s))/Cds1}
C_Cds2  edep2      s  {Cds1}
C_Cgs       g      s  {Cgs0}
.FUNC I0(Uee,p,pp,z1,cc)  {if(Uee>pp,(Uee-cc*z1)*z1,p*(pp-p)/cc*exp((Uee-pp)/p))}
.FUNC Ig(Uds,T,p,Uee,cc)  {fpar8*(fpar38/T)**fpar9*I0(Uee,p,min(2*p,p+cc*Uds),min(Uds,Uee/(2*cc)),cc)}
.FUNC J(d,g,T,da,s)
+ {a*(s*(Ig(da,T,fpar10*fpar37*T,g-Vth+fpar2*(T-fpar39),fpar11)+1*exp(min(fpar14+(d-fpar15-fpar16*(T-fpar39))/fpar13,25))))}
G_chan    d    s  VALUE={J(V(d,s),V(g,s),fpar38+limit(V(Tj),-200,499),(SQRT(1+4*fpar12*abs(V(d,s)))-1)/2/fpar12,sgn(V(d,s)))}
V_Ichannel d1 d 0
.FUNC Rd0(T)  {(fpar7*dRd+(1-fpar7)*dRd*(T/fpar39)**fpar6)}
.FUNC CF(T,Iepi) {(fpar4**2)/max(1,fpar4**2-(Rd0(T)*Iepi)**limit(2+fpar3*(T-fpar39),1.2,3))}
V_Iepi     dd d2 0
G_G_Rd     d2 d1 VALUE {V(d2,d1)/(Rd0(fpar38+LIMIT(V(t1),-200,999))*CF(fpar38+LIMIT(V(t1),-200,999),abs(I(V_Iepi))))}
Dbody s dio dbody
.model dbody D (BV={fpar15*10}, CJO ={Cdio}, TT={fpar19}, IS ={a*(fpar18)} m={0.5} RS={dRdi} N={fpar20} XTI=0.0)
V_sense2 dd   dio  0
R_R_ERd_g  d2 d1  10k
R1        g    s    1G
Rd01      d    s    500Meg
Rd02     d2    s    500Meg
G_G_Ptot_channel 0 Tj VALUE {heat*LIMIT(V(d,s)*I(V_Ichannel),0,100k) }
G_G_Ptot_Epi     0 t1 VALUE {heat*(LIMIT(V(dd,d1)*I(V_Iepi),0,100k)+LIMIT(V(dd,s)*I(V_sense2),0,100k))}
.ENDS
.SUBCKT IPW65R018CM8_L1 drain gate source PARAMS: dVth=0 dRdson=0
.PARAM Rs=4.38E-04    Rg=0.86    Rdp=7.44E-05          Ls=3.12E-09        Ld=1.94E-09
.PARAM Lg=8.38E-09    act=29.67        Inn={1*29.67}  Unn=10       Rmax=18m
X1  dd g s Tj Tj cool_C8_650_var PARAMS: a={act} dVth={dVth} dR={dRdson} Inn={Inn} Unn={Unn}
                                      +Rmax={Rmax} Rs={Rs} Rdp={Rdp} heat=0
L_Ld         drain  ldrd    {Ld}
R_Ld         drain  ldrd    10
R_Rd         dd     ldrd    {Rdp}
L_Ls         source lsrs  {Ls}
R_Ls         source lsrs  10
R_Rs         s      lsrs  {Rs}
L_Lg         gate   lgrg  {Lg}
R_Lg         gate   lgrg  10
R_Rg         lgrg   g     {Rg}
E1    Tj     w      VALUE={TEMP}
R1    w      0      1u
.ENDS

.include /Users/bennet/Desktop/temper/worktrees/ps-integrate/zapote/power-stage-120v/validation-plan/sim-kit/common/options.inc
.param RG=100 TJ=25 STEP=0.2n IFWD=58.2
.include params.inc
.param TJDECK={TJ}
.temp {TJ}
Vbus bus 0 400
XQH bus gh sw IPW65R018CM8_L1
Vprobe sw drain 0
XQD drain gd 0 IPW65R018CM8_L1
* Equal external gate resistors, as datasheet Table 8.
Roff gd 0 {RG}
Vcmd cmd sw PULSE(0 13 2u 5n 5n 20u 40u)
Ron cmd gh {RG}
Iload sw 0 PWL(0 0 1u {IFWD})
.tran {STEP} 12u 0 {STEP}
.save v(sw) v(xqd.dd) v(xqd.s) v(xqd.g) i(vprobe)
.meas tran peak MAX i(vprobe) from=2u to=12u
.end
