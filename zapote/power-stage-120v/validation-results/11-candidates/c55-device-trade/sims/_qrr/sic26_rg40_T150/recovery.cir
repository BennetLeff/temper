* Table 8 clamped-inductive commutation; ideal constant-current load limit.
.include IFX_CFD7_650V.lib
.include /Users/bennet/Desktop/temper/worktrees/runs-native21/c55-dl/_c55_clean/sic_g2.lib
.SUBCKT SiCMOS_650V_gen2_C55	dd gg ss Pj Tj    PARAMS: dVth=0 fpar127={1.0}
*?@ Start SIMPLIS Encryption $$WC_SIMPLIS_ENCRYPT_TAG$$
	.PARAM fpar2 = {fpar127}
	.PARAM fpar3 = {LIMIT(-1.306*ln(fpar127)+5.0069,0.1,25)}
	.PARAM fpar4 = {1.0}
	.PARAM fpar5 = {1.0}
	.PARAM fpar6 = {1.0 * fpar2}
	.PARAM fpar7 = {1.0 * fpar2}
	.PARAM fpar8 = {1.0 * fpar2}
	.PARAM fpar9 = {1.0 * fpar2}
	.PARAM fpar10 = {1.0 * fpar2}
	X$CGDAA	gi	dd2		CGDAA		PARAMS: fpar11 = {fpar6} fpar12 = {fpar7}
	RPCGD	gi	dd2		10G
	RSCGD	dd	dd2		10m
	X$CDS	dd1	sx		CDSAA		PARAMS: fpar40 = {fpar9} fpar41 = {fpar10}
	RPCDS	dd1	sx		10G
	RSCDS	dd	dd1		10m
	X$CGS	gi	ss1		CGSAA		PARAMS: fpar56 = {fpar8}
	RPCGS	gi	ss1		10G
	RSCGS	ss1	sx		10m
	RGint	gg	gi	1e-6
	X$MF	dd	gi	sx	Tj	MF	PARAMS: fpar61 = {fpar4} fpar62 = {fpar5} dVth = {dVth} fpar133 = {fpar2}
	X$BD	sx	dd	gi Tj BodyDiodeModel_qrr_v1 PARAMS: fpar107 = {fpar2}
	VIPow	sx	ss	DC=0
	G_Pow  0   Pj   VALUE = {LIMIT( I(VIPow)*(V(dd,ss))  ,-100k,100k) }
	R_Pow  0   Pj  1
*?@ End SIMPLIS Encryption
.ENDS
.SUBCKT IMW65R026M2H_C55 drain gate source PARAMS: dVth=0 Ls=3.52E-09 Ld=2.25E-09 Lg=8.95E-09
.PARAM Rs=6.17E-04      Rg=4.50E-02       Rd=7.67E-05       fpar127=5.00
Lg    gate   g1   {Lg}
Rg    g1     g    {Rg+LIMIT(-1.306*ln(fpar127)+5.0069,0.1,25)}
Rgcon gate   g1   1.0
Ls    source s1   {Ls}
Rs    s1     s    {Rs}
Rscon source s1   1.0
Ld    drain  ldrd   {Ld}
Rd    ldrd     dd   {Rd}
Rdcon drain  ldrd   1.0
X$MF  dd     g     s  Pow	Tj  SiCMOS_650V_gen2_C55    PARAMS: dVth={dVth} fpar127={fpar127}
ETj	Tj	w	VALUE = {TEMP}
RTj	w	0	1u
.ENDS

.include /Users/bennet/Desktop/temper/worktrees/ps-integrate/zapote/power-stage-120v/validation-plan/sim-kit/common/options.inc
.param RG=100 TJ=25 STEP=0.2n IFWD=58.2
.include params.inc
.param TJDECK={TJ}
.temp {TJ}
Vbus bus 0 400
XQH bus gh sw IMW65R026M2H_C55
Vprobe sw drain 0
XQD drain gd 0 IMW65R026M2H_C55
* Equal external gate resistors, as datasheet Table 8.
Roff gd 0 {RG}
Vcmd cmd sw PULSE(0 13 2u 5n 5n 20u 40u)
Ron cmd gh {RG}
Iload sw 0 PWL(0 0 1u {IFWD})
.tran {STEP} 12u 0 {STEP}
.save v(sw) v(xqd.dd) v(xqd.s) v(xqd.g) i(vprobe)
.meas tran peak MAX i(vprobe) from=2u to=12u
.end
