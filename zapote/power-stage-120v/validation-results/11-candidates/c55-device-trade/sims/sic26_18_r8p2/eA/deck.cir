* Round 17 D2: complementary half-bridge leg with the FEM board inductance
* matrix as four coupled inductors (one per FEM port), one transition.
* Built from round 3's complementary_leg.cir (same driver approximation,
* Infineon L1 models, snubbers, shunt, load, solver options).
*
* Board copper: the 4x4 FEM matrix (h -> 0) maps onto
*   L_P1  in series with C38's branch   (port P1: C38.1 bus_p -> C38.2 hv_ret)
*   L_P2  in series with C39's branch   (port P2: C39.1 bus_p -> C39.2 hv_ret)
*   L_P3  in the high-side gate path    (port P3: driver out_h -> sw, i.e. +
*         is gate-discharge current, gate -> driver)
*   L_P4  in the low-side gate path     (port P4: driver out_l -> leg_ret)
* coupled by K (k_ij = L_ij/sqrt(L_ii L_jj)). Each inductor's first node is
* the end where FEM port current enters (the port's 'a' side), so the K
* signs carry over. The FEM shorted the FETs, gate resistors and shunt at
* their pads (closures), so those parts sit in the SPICE loops at the same
* places; the FEM ports were at the capacitors and the driver pins.
* The common-source effect is the P1/P2-to-P3/P4 coupling (no separate LCS).
*
* NOT from the FEM: LBULK (bulk-capacitor path, round-3 heuristic copper
* value), capacitor ESL LESL (TDK bound <= ~20 nH, PACKAGE-INDUCTANCE.md),
* shunt inductance LSHUNT (Vishay 0.5-5 nH). The Infineon L1 subcircuit
* already contains the TO-247 leads (Ld 1.88, Ls 2.82, Lg 8.32 nH) and
* Rg,int 2.7 ohm: do not add package L again.

.include IFX_CFD7_650V.lib
.include /Users/bennet/Desktop/temper/worktrees/runs-native21/c55-dl/_c55_clean/sic_g2.lib
.SUBCKT SiCMOS_650V_gen2_C55	dd gg ss Pj Tj    PARAMS: dVth=0 fpar127={1.0}
*?@ Start SIMPLIS Encryption $$WC_SIMPLIS_ENCRYPT_TAG$$
	.PARAM fpar2 = {fpar127}
	.PARAM fpar3 = {LIMIT(-1.306*ln(fpar127)+5.0069,0.1,25)}
	.PARAM fpar4 = {1.0}
	.PARAM fpar5 = {1.0}
	.PARAM fpar6 = {1.0 * fpar2}
	.PARAM fpar7 = {1.0 * fpar2}
	.PARAM fpar8 = {1.0 * fpar2}
	.PARAM fpar9 = {1.0 * fpar2}
	.PARAM fpar10 = {1.0 * fpar2}
	X$CGDAA	gi	dd2		CGDAA		PARAMS: fpar11 = {fpar6} fpar12 = {fpar7}
	RPCGD	gi	dd2		10G
	RSCGD	dd	dd2		10m
	X$CDS	dd1	sx		CDSAA		PARAMS: fpar40 = {fpar9} fpar41 = {fpar10}
	RPCDS	dd1	sx		10G
	RSCDS	dd	dd1		10m
	X$CGS	gi	ss1		CGSAA		PARAMS: fpar56 = {fpar8}
	RPCGS	gi	ss1		10G
	RSCGS	ss1	sx		10m
	RGint	gg	gi	1e-6
	X$MF	dd	gi	sx	Tj	MF	PARAMS: fpar61 = {fpar4} fpar62 = {fpar5} dVth = {dVth} fpar133 = {fpar2}
	X$BD	sx	dd	gi Tj BodyDiodeModel_qrr_v1 PARAMS: fpar107 = {fpar2}
	VIPow	sx	ss	DC=0
	G_Pow  0   Pj   VALUE = {LIMIT( I(VIPow)*(V(dd,ss))  ,-100k,100k) }
	R_Pow  0   Pj  1
*?@ End SIMPLIS Encryption
.ENDS
.SUBCKT IMW65R026M2H_C55 drain gate source PARAMS: dVth=0 Ls=3.52E-09 Ld=2.25E-09 Lg=8.95E-09
.PARAM Rs=6.17E-04      Rg=4.50E-02       Rd=7.67E-05       fpar127=5.00
Lg    gate   g1   {Lg}
Rg    g1     g    {Rg+LIMIT(-1.306*ln(fpar127)+5.0069,0.1,25)}
Rgcon gate   g1   1.0
Ls    source s1   {Ls}
Rs    s1     s    {Rs}
Rscon source s1   1.0
Ld    drain  ldrd   {Ld}
Rd    ldrd     dd   {Rd}
Rdcon drain  ldrd   1.0
X$MF  dd     g     s  Pow	Tj  SiCMOS_650V_gen2_C55    PARAMS: dVth={dVth} fpar127={fpar127}
ETj	Tj	w	VALUE = {TEMP}
RTj	w	0	1u
.ENDS

.include ../common/options.inc

* ---- defaults; params.inc (written by the runner) overrides them
.param VBUS=170 IL=37 DIR=0 T1=2u DT=348n TRMAX=0.2n
.param LP1=26n LP2=26n LP3=20n LP4=20n K12=0.6 K13=0.1 K14=0.15 K23=0.1 K24=0.15 K34=0
.param LESL=10n LSHUNT=2n LBULK=21.519n RG=3.9 ROL=0.55 ROH=5 VDRV=15 CSNUB=1n
.param C38=0.1u C39=0.1u CBULK=5.4u
.param ROFF=1.34482758621 CGS=1n RDPX=7.67e-05
.param VOFFP=-1.6
.include params.inc
.param TJDECK={TJ}
.options itl4=100000
.temp {TJ}
.param GL0={VDRV*(1-DIR)} GL1={VDRV*DIR}
.param GH0={VDRV*DIR} GH1={VDRV*(1-DIR)}
.param TLS={T1+DIR*DT} THS={T1+(1-DIR)*DT}
.param ILOAD_SIGNED={IL*(1-2*DIR)}

* ---- DC bus: bulk path (not FEM) and the two local film capacitors
Vbus src 0 {VBUS}
Rsrc src bulk 10m
Cbulk bulk 0 {CBULK}
Lbulk bulk bus {LBULK}
L_P1 bus c38a {LP1}
Lesl38 c38a c38b {LESL}
Rc38 c38b c38c 5m
Cc38 c38c 0 {C38}
L_P2 bus c39a {LP2}
Lesl39 c39a c39b {LESL}
Rc39 c39b c39c 5m
Cc39 c39c 0 {C39}

* ---- power path: bus -> HS -> sw -> LS -> shunt -> 0 (board L is in L_P1/L_P2)
XQH bus g_hs sw IMW65R026M2H_C55
Vids sw d_ls 0
XQL d_ls g_ls s_ls IMW65R026M2H_C55
Lshunt s_ls shunt {LSHUNT}
Rshunt shunt 0 1m
Csnh bus sw {CSNUB}
Csnl d_ls s_ls {CSNUB}

* ---- load (ramped from 0 for a consistent operating point)
Iload bus sw PWL(0 0 1u {ILOAD_SIGNED})

* ---- drivers: output-resistance approximation (round 3), then the gate
* resistor, then the board gate-loop inductor (first node at the gate)
Vgl_cmd gl_cmd s_ls PULSE({GL0} {GL1} {TLS} 5n 5n 10u 20u)
Bgl gdl s_ls I={(v(gdl,s_ls)-(VOFFP))*(1-v(gl_cmd,s_ls)/VDRV)/ROL+(v(gdl,s_ls)-VDRV)*v(gl_cmd,s_ls)/(VDRV*ROH)}
Rgl gdl gdl3 {RG}
L_P4 g_ls gdl3 {LP4}
Rholdl g_ls s_ls 10k
Vgh_cmd gh_cmd sw PULSE({GH0} {GH1} {THS} 5n 5n 10u 20u)
Bgh gdh sw I={(v(gdh,sw)-(VOFFP))*(1-v(gh_cmd,sw)/VDRV)/ROL+(v(gdh,sw)-VDRV)*v(gh_cmd,sw)/(VDRV*ROH)}
Rgh gdh gdh3 {RG}
L_P3 g_hs gdh3 {LP3}
Rholdh g_hs sw 10k

* ---- FEM couplings
K12 L_P1 L_P2 {K12}
K13 L_P1 L_P3 {K13}
K14 L_P1 L_P4 {K14}
K23 L_P2 L_P3 {K23}
K24 L_P2 L_P4 {K24}
K34 L_P3 L_P4 {K34}

.tran {TRMAX} {T1+DT+3.8u} 0 {TRMAX}
.save v(sw) v(bus) v(xql.dd) v(xql.g) v(xql.s) v(xqh.dd) v(xqh.g) v(xqh.s) v(gl_cmd) v(gh_cmd) i(vids)

.meas tran vds_ls_die_pk MAX par('v(xql.dd)-v(xql.s)') from={T1} to={T1+DT+0.75u}
.meas tran vds_hs_die_pk MAX par('v(xqh.dd)-v(xqh.s)') from={T1} to={T1+DT+0.75u}
.meas tran vgs_ls_die_max MAX par('v(xql.g)-v(xql.s)') from={T1} to={T1+DT+0.75u}
.meas tran vgs_ls_die_min MIN par('v(xql.g)-v(xql.s)') from={T1} to={T1+DT+0.75u}
.meas tran vgs_hs_die_max MAX par('v(xqh.g)-v(xqh.s)') from={T1} to={T1+DT+0.75u}
.meas tran vgs_hs_die_min MIN par('v(xqh.g)-v(xqh.s)') from={T1} to={T1+DT+0.75u}
* Off-device gate during the partner's turn-on (false turn-on check): the
* device turned off at T1 (LS for DIR=0, HS for DIR=1), from the partner's
* on command to the end of the window.
.meas tran vgs_ls_off_max MAX par('v(xql.g)-v(xql.s)') from={T1+DT} to={T1+DT+0.75u}
.meas tran vgs_hs_off_max MAX par('v(xqh.g)-v(xqh.s)') from={T1+DT} to={T1+DT+0.75u}
* Incoming device's die VDS at its own on command (ZVS check: ~0 V means
* the load current already discharged it): HS at THS for DIR=0, LS at TLS for
* DIR=1 (each measured for both directions; the runner picks the right one).
.meas tran vds_hs_at_on FIND par('v(xqh.dd)-v(xqh.s)') AT={THS}
.meas tran vds_ls_at_on FIND par('v(xql.dd)-v(xql.s)') AT={TLS}
* Turned-off device's die VGS at the partner's on command (T1+DT): above
* threshold there means the dead time was too short (shoot-through risk), as
* opposed to a later rebound (false turn-on).
.meas tran vgs_ls_at_partner FIND par('v(xql.g)-v(xql.s)') AT={T1+DT}
.meas tran vgs_hs_at_partner FIND par('v(xqh.g)-v(xqh.s)') AT={T1+DT}
* D6 off1_c1_neg2: generic proposed remedy; no layout added.
.include /Users/bennet/Desktop/temper/worktrees/ps-integrate/zapote/power-stage-120v/validation-plan/sim-kit/models/vendor/PMEG6030EP.txt
XDoffl gdl3 offl PMEG6030EP
Roffl offl gdl {ROFF}
XDoffh gdh3 offh PMEG6030EP
Roffh offh gdh {ROFF}
Cgsl g_ls s_ls {CGS}
Cgsh g_hs sw {CGS}
.meas tran e_l_pre INTEG par('max(0,(v(xql.dd)-v(xql.s))*(v(xql.ldrd)-v(xql.dd))/7.44e-5)') from={T1} to={T1+DT}
.meas tran e_l_post INTEG par('max(0,(v(xql.dd)-v(xql.s))*(v(xql.ldrd)-v(xql.dd))/7.44e-5)') from={T1+DT} to={T1+DT+0.75u}
.meas tran e_h_pre INTEG par('max(0,(v(xqh.dd)-v(xqh.s))*(v(xqh.ldrd)-v(xqh.dd))/7.44e-5)') from={T1} to={T1+DT}
.meas tran e_h_post INTEG par('max(0,(v(xqh.dd)-v(xqh.s))*(v(xqh.ldrd)-v(xqh.dd))/7.44e-5)') from={T1+DT} to={T1+DT+0.75u}

* ---- c33 adoption: board switch-node capacitance (plane-pair screen) and the ZVS crossing time
Cbrd_ret sw 0 {CBRD_RET}
Cbrd_bus sw bus {CBRD_BUS}
.meas tran t_hs_zvs WHEN par('v(xqh.dd)-v(xqh.s)')={0.05*VBUS} FALL=1 TD={T1}
.meas tran t_ls_zvs WHEN par('v(xql.dd)-v(xql.s)')={0.05*VBUS} FALL=1 TD={T1}

* ---- c25 dv/dt probes (measurement only; V/ns)
Bdvsw dvsw 0 V={ddt(v(sw))*1e-9}
Bdvls dvls 0 V={ddt(v(xql.dd)-v(xql.s))*1e-9}
Bdvhs dvhs 0 V={ddt(v(xqh.dd)-v(xqh.s))*1e-9}
.meas tran dvsw_max MAX v(dvsw) from={T1} to={T1+DT+0.75u}
.meas tran dvsw_min MIN v(dvsw) from={T1} to={T1+DT+0.75u}
.meas tran dvls_max MAX v(dvls) from={T1} to={T1+DT+0.75u}
.meas tran dvls_min MIN v(dvls) from={T1} to={T1+DT+0.75u}
.meas tran dvhs_max MAX v(dvhs) from={T1} to={T1+DT+0.75u}
.meas tran dvhs_min MIN v(dvhs) from={T1} to={T1+DT+0.75u}
* 20-80 % switch-node edge time (board node sw vs leg return), first crossing after T1
.meas tran tr2080 TRIG v(sw) VAL={0.2*VBUS} RISE=1 TD={T1} TARG v(sw) VAL={0.8*VBUS} RISE=1 TD={T1}
.meas tran tf8020 TRIG v(sw) VAL={0.8*VBUS} FALL=1 TD={T1} TARG v(sw) VAL={0.2*VBUS} FALL=1 TD={T1}
.meas tran tr1090 TRIG v(sw) VAL={0.1*VBUS} RISE=1 TD={T1} TARG v(sw) VAL={0.9*VBUS} RISE=1 TD={T1}
.meas tran tf9010 TRIG v(sw) VAL={0.9*VBUS} FALL=1 TD={T1} TARG v(sw) VAL={0.1*VBUS} FALL=1 TD={T1}

* ---- device study: window and gate-loop charge (post-processing .meas only; no added elements)
.param TW0={T1-20n} TW1={T1+DT+3.75u}
.save i(l_p3) i(l_p4)
* gate-loop charge (L_P3/L_P4 carry the whole gate current incl. the 1 nF Cgs and the PMEG branch; + = gate discharge)
.meas tran qh_win INTEG i(l_p3) from={TW0} to={TW1}
.meas tran ql_win INTEG i(l_p4) from={TW0} to={TW1}

* ---- gate-network study: commutated-diode current (die drain current, + into drain) and edge measures
.save v(xql.ldrd) v(xqh.ldrd) v(xql.dd) v(xqh.dd) v(g_ls) v(g_hs) v(gdl3) v(gdh3)
.param IABS={abs(IL)+1e-3}
.meas tran ild_min MIN par('(v(xql.ldrd)-v(xql.dd))/RDPX') from={T1} to={T1+DT+0.75u}
.meas tran ild_max MAX par('(v(xql.ldrd)-v(xql.dd))/RDPX') from={T1+DT} to={T1+DT+0.75u}
.meas tran ihd_min MIN par('(v(xqh.ldrd)-v(xqh.dd))/RDPX') from={T1} to={T1+DT+0.75u}
.meas tran ihd_max MAX par('(v(xqh.ldrd)-v(xqh.dd))/RDPX') from={T1+DT} to={T1+DT+0.75u}
.meas tran tl75 WHEN par('(v(xql.ldrd)-v(xql.dd))/RDPX')={-0.75*IABS} RISE=1 TD={T1+DT}
.meas tran tl50 WHEN par('(v(xql.ldrd)-v(xql.dd))/RDPX')={-0.50*IABS} RISE=1 TD={T1+DT}
.meas tran tl25 WHEN par('(v(xql.ldrd)-v(xql.dd))/RDPX')={-0.25*IABS} RISE=1 TD={T1+DT}
.meas tran tl00 WHEN par('(v(xql.ldrd)-v(xql.dd))/RDPX')=0 RISE=1 TD={T1+DT}
.meas tran th75 WHEN par('(v(xqh.ldrd)-v(xqh.dd))/RDPX')={-0.75*IABS} RISE=1 TD={T1+DT}
.meas tran th50 WHEN par('(v(xqh.ldrd)-v(xqh.dd))/RDPX')={-0.50*IABS} RISE=1 TD={T1+DT}
.meas tran th25 WHEN par('(v(xqh.ldrd)-v(xqh.dd))/RDPX')={-0.25*IABS} RISE=1 TD={T1+DT}
.meas tran th00 WHEN par('(v(xqh.ldrd)-v(xqh.dd))/RDPX')=0 RISE=1 TD={T1+DT}
* energy dissipated in the series gate resistors (R_on) and the turn-off branch resistors over the window
.save v(gdl) v(gdh) v(offl) v(offh)
.meas tran e_rgl INTEG par('(v(gdl)-v(gdl3))*(v(gdl)-v(gdl3))/RG') from={T1-20n} to={T1+DT+0.75u}
.meas tran e_rgh INTEG par('(v(gdh)-v(gdh3))*(v(gdh)-v(gdh3))/RG') from={T1-20n} to={T1+DT+0.75u}
* incoming gate (die) reaching 4 V / 10 V after its on command (turn-on delay, plateau exit)
.meas tran tgh4 WHEN par('v(xqh.g)-v(xqh.s)')=4 RISE=1 TD={THS}
.meas tran tgl4 WHEN par('v(xql.g)-v(xql.s)')=4 RISE=1 TD={TLS}
.meas tran tgh10 WHEN par('v(xqh.g)-v(xqh.s)')=10 RISE=1 TD={THS}
.meas tran tgl10 WHEN par('v(xql.g)-v(xql.s)')=10 RISE=1 TD={TLS}

* ---- slow-gate check: incoming die gate voltage after its on command (long window)
.meas tran vgh_1u FIND par('v(xqh.g)-v(xqh.s)') AT={THS+1u}
.meas tran vgl_1u FIND par('v(xql.g)-v(xql.s)') AT={TLS+1u}
.meas tran vgh_2u FIND par('v(xqh.g)-v(xqh.s)') AT={THS+2u}
.meas tran vgl_2u FIND par('v(xql.g)-v(xql.s)') AT={TLS+2u}
.meas tran vgh_3u FIND par('v(xqh.g)-v(xqh.s)') AT={THS+3u}
.meas tran vgl_3u FIND par('v(xql.g)-v(xql.s)') AT={TLS+3u}

* ---- c55: generic die heat (v(dd,s) x die drain current), both dies, over the device-study window
.meas tran eg_hs INTEG par('(v(xqh.dd)-v(xqh.s))*(v(xqh.ldrd)-v(xqh.dd))/RDPX') from={TW0} to={TW1}
.meas tran eg_ls INTEG par('(v(xql.dd)-v(xql.s))*(v(xql.ldrd)-v(xql.dd))/RDPX') from={TW0} to={TW1}
.meas tran pg_hs_end FIND par('(v(xqh.dd)-v(xqh.s))*(v(xqh.ldrd)-v(xqh.dd))/RDPX') AT={TW1-5n}
.meas tran pg_ls_end FIND par('(v(xql.dd)-v(xql.s))*(v(xql.ldrd)-v(xql.dd))/RDPX') AT={TW1-5n}
.meas tran pg_hs_start FIND par('(v(xqh.dd)-v(xqh.s))*(v(xqh.ldrd)-v(xqh.dd))/RDPX') AT={TW0}
.meas tran pg_ls_start FIND par('(v(xql.dd)-v(xql.s))*(v(xql.ldrd)-v(xql.dd))/RDPX') AT={TW0}
.end
