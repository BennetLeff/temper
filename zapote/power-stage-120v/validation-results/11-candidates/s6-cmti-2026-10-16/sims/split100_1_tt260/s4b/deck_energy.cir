* Round 17 D2: complementary half-bridge leg with the FEM board inductance
* matrix as four coupled inductors (one per FEM port), one transition.
* Built from round 3's complementary_leg.cir (same driver approximation,
* Infineon L1 models, snubbers, shunt, load, solver options).
*
* Board copper: the 4x4 FEM matrix (h -> 0) maps onto
*   L_P1  in series with C38's branch   (port P1: C38.1 bus_p -> C38.2 hv_ret)
*   L_P2  in series with C39's branch   (port P2: C39.1 bus_p -> C39.2 hv_ret)
*   L_P3  in the high-side gate path    (port P3: driver out_h -> sw, i.e. +
*         is gate-discharge current, gate -> driver)
*   L_P4  in the low-side gate path     (port P4: driver out_l -> leg_ret)
* coupled by K (k_ij = L_ij/sqrt(L_ii L_jj)). Each inductor's first node is
* the end where FEM port current enters (the port's 'a' side), so the K
* signs carry over. The FEM shorted the FETs, gate resistors and shunt at
* their pads (closures), so those parts sit in the SPICE loops at the same
* places; the FEM ports were at the capacitors and the driver pins.
* The common-source effect is the P1/P2-to-P3/P4 coupling (no separate LCS).
*
* NOT from the FEM: LBULK (bulk-capacitor path, round-3 heuristic copper
* value), capacitor ESL LESL (TDK bound <= ~20 nH, PACKAGE-INDUCTANCE.md),
* shunt inductance LSHUNT (Vishay 0.5-5 nH). The Infineon L1 subcircuit
* already contains the TO-247 leads (Ld 1.88, Ls 2.82, Lg 8.32 nH) and
* Rg,int 2.7 ohm: do not add package L again.

.include IFX_CFD7_650V.lib
.SUBCKT cool_tech_w3_tt dd g s Tj t1 PARAMS: a=1 dVth=0 dR=0 Inn=1 Unn=1 Rmax=1
+gmin=1 Rs=1 Rdp=1 heat=0
.PARAM  fpar42=298
.PARAM  fpar1=4.834
.PARAM  fpar2=0.00547
.PARAM  fpar3=-0.002
.PARAM  fpar4=19.1
.PARAM  fpar5={0.965*0.82}
.PARAM  fpar6=3.06
.PARAM  fpar7=0.339
.PARAM  MOS_b0_a_ref=35.81
.PARAM  MOS_b0_exp=0.1
.PARAM  fpar8=4.8745
.PARAM  fpar9=1.163575
.PARAM  fpar10=5.48
.PARAM  fpar11=0.905
.PARAM  fpar12=2.416
.PARAM  fpar13=0.314
.PARAM  fpar14=-21.85
.PARAM  fpar15=715
.PARAM  fpar16=0.715
.PARAM  fpar18={0.2757*0.85}
.PARAM  fpar19={-25.9158*0.95}
.PARAM  fpar20=260e-9
.PARAM  fpar21=1.1663
.PARAM  fpar22=0.228
.PARAM  fpar23=1.47e-15
.PARAM  CAP_CdgN1A=1.347e-10
.PARAM  CAP_CdgN1P=1e-10
.PARAM  fpar26=5.14e-12
.PARAM  fpar27=1.6e-15
.PARAM  fpar28=1e-16
.PARAM  fpar29=1.15e-11
.PARAM  fpar30=4e-13
.PARAM  fpar31=9.99e-14
.PARAM  fpar32=90
.PARAM  fpar33=1.7e-12
.PARAM  fpar34=19e-013
.PARAM  fpar35=5.136e-10
.PARAM  fpar36=1.0414835e-07
.PARAM  fpar37=3.67454e-09
.PARAM  fpar38=1.995e-10
.PARAM  fpar39=1e-12
.PARAM  fpar17=0.0
.PARAM	fpar40=85.8u
.PARAM  fpar41=273
.PARAM  dRdi={fpar18/a}
.PARAM  Cdio={fpar23*a}
.PARAM  Cdg1={CAP_CdgN1A*a+CAP_CdgN1P*SQRT(a)}
.PARAM  Cdg2={fpar26*a}
.PARAM  CdgV1={fpar27*a}
.PARAM  CdgV2={(fpar31*a+fpar28)}
.PARAM  Cds0={fpar33*a+fpar34*SQRT(a)}
.PARAM  Cds1={a*fpar35}
.PARAM  Cgs0={fpar38*a+fpar39*(SQRT(a))}
.PARAM  MOS_b0_a={fpar8*(MOS_b0_a_ref/a)**MOS_b0_exp}
.PARAM  Vmin=3.4   Vmax=5.4
.PARAM  Vth={fpar1+(Vmax-fpar1)*limit(dVth,0,1)-(Vmin-fpar1)*limit(dVth,-1,0)}
.PARAM  r0={MOS_b0_a*((fpar41/fpar42)**fpar9)*a}
.PARAM  r1={(Unn-Inn*Rs-fpar1)*r0}
.PARAM  r2={(fpar17*SQRT(0.4)-fpar11)*Inn*r0}
.PARAM  Rlim={(r1+2*r2*Rmax-SQRT(r1**2+4*r2))/(2*r2)}
.PARAM  dRd={fpar5/a+if(dVth==0,limit(dR,0,1)*max(Rlim-fpar5/a-Rs-Rdp,0),0)}
.PARAM  CAP_eedg=-0.556
.PARAM  x0={(fpar29-fpar26)/fpar30}  x1={fpar29/fpar30} dx={x1-x0}
.FUNC 	QCdg1(x) {Cdg2*min(x,x1)+CdgV2*max(x-x1,0)+CdgV1/2*max(0, x-fpar32)**2+(Cdg2-CdgV2)*((limit(x,x0,x1)-x0)**3/(dx*dx)*((limit(x,x0,x1)-x0)/(2*dx)-1))}
.PARAM  Eds1={-6000}	Eds2={-320}	Eds3={-200}	eeds1={-0.1667}	eeds2={-6.25m}  eeds3={-0.05}
.PARAM 	a0={(fpar36-fpar35)/fpar37} a1={fpar36/fpar37} da={a1-a0}
.FUNC 	QCds1(x) {Cds1*min(x,a1)+Cds1*((limit(x,a0,a1)-a0)**3/(da*da)*((limit(x,a0,a1)-a0)/(2*da)-1))}
E_Edg1     d1     ox  VALUE {if(V(d1,g)>0,V(d1,g)-(exp(CAP_eedg*max(V(d1,g),0))-1)/CAP_eedg,0)}
C_Cdg1     ox      g  {Cdg1}
E_Edg2     d1    ox2  VALUE {V(d1,g)-QCdg1(V(d1,g))/Cdg2}
C_Cdg2    ox2      g  {Cdg2}
C_Cds0     d1      s  {Cds0}
E_Eds1     d1  edep1  VALUE {if(V(d1,s)>0,V(d1,s)-Eds1*(exp(eeds1*max(V(d1,s),0))-1)-Eds2*(exp(eeds2*max(V(d1,s),0))-1)-Eds3*(exp(eeds3*max(V(d1,s),0))-1),0)}
C_Cds1  edep1      s  {Cds0}
E_Eds2     d1  edep2  VALUE {V(d1,s)-QCds1(V(d1,s))/Cds1}
C_Cds2  edep2      s  {Cds1}
C_Cgs       g      s  {Cgs0}
.FUNC I0(Uee,p,pp,z1,cc)  {if(Uee>pp,(Uee-cc*z1)*z1,p*(pp-p)/cc*exp((Uee-pp)/p))}
.FUNC Ig(Uds,T,p,Uee,cc)  {MOS_b0_a*(fpar41/T)**fpar9*I0(Uee,p,min(2*p,p+cc*Uds),min(Uds,Uee/(2*cc)),cc)}
.FUNC J(d,g,T,da,s)
+ {a*(s*(Ig(da,T,fpar10*fpar40*T,g-Vth+fpar2*(T-fpar42),fpar11)+1*exp(min(fpar14+(d-fpar15-fpar16*(T-fpar42))/fpar13,25))))}
G_chan    d    s  VALUE={J(V(d,s),V(g,s),fpar41+limit(V(Tj),-200,499),(SQRT(1+4*fpar12*abs(V(d,s)))-1)/2/fpar12,sgn(V(d,s)))}
V_Ichannel d1 d 0
.FUNC Rd0(T)  {(fpar7*dRd+(1-fpar7)*dRd*(T/fpar42)**fpar6)}
.FUNC CF(T,Iepi) {(fpar4**2)/max(1,fpar4**2-(Rd0(T)*Iepi)**limit(2+fpar3*(T-fpar42),1.2,3))}
V_Iepi     dd d2 0
G_G_Rd     d2 d1 VALUE {V(d2,d1)/(Rd0(fpar41+LIMIT(V(t1),-200,999))*CF(fpar41+LIMIT(V(t1),-200,999),abs(I(V_Iepi))))}
Dbody s dio dbody
.model dbody D (BV={fpar15*10}, CJO ={Cdio}, TT={fpar20}, IS ={a*exp(fpar19)} m={0.3} RS={dRdi/100} N={fpar21} )
G_Rdio   dio2   dd  VALUE={V(dio2,dd)/(dRdi*((limit(V(Tj),-200,999)+fpar41)/fpar42)**fpar22)}
V_sense2 dio2   dio  0
R_R_ERd_g  d2 d1  10k
R1        g    s    1G
Rd01      d    s    500Meg
Rd02     d2    s    500Meg
Rd03     dio   s    500Meg
G_G_Ptot_channel 0 Tj VALUE {heat*LIMIT(V(d,s)*I(V_Ichannel),0,100k) }
G_G_Ptot_Epi     0 t1 VALUE {heat*(LIMIT(V(dd,d1)*I(V_Iepi),0,100k)+LIMIT(V(dd,s)*I(V_sense2),0,100k))}
.ENDS
.SUBCKT IPW65R018CFD7_TT drain gate source PARAMS: dVth=0 dRdson=0
.PARAM Rs=3.42E-04    Rg=2.7    Rdp=7.44E-05          Ls=2.82E-09        Ld=1.88E-09
.PARAM Lg=8.32E-09    act=58.23        Inn={1.0*58.23}  Unn=10.0       Rmax=18m
X1  dd g s Tj Tj cool_tech_w3_tt PARAMS: a={act} dVth={dVth} dR={dRdson} Inn={Inn} Unn={Unn}
                                      +Rmax={Rmax} Rs={Rs} Rdp={Rdp} heat=0
L_Ld         drain  ldrd    {Ld}
R_Ld         drain  ldrd    10
R_Rd         dd     ldrd    {Rdp}
L_Ls         source lsrs  {Ls}
R_Ls         source lsrs  10
R_Rs         s      lsrs  {Rs}
L_Lg         gate   lgrg  {Lg}
R_Lg         gate   lgrg  10
R_Rg         lgrg   g     {Rg}
E1    Tj     w      VALUE={TEMP}
R1    w      0      1u
.ENDS
.include ../common/options.inc

* ---- defaults; params.inc (written by the runner) overrides them
.param VBUS=170 IL=37 DIR=0 T1=2u DT=348n TRMAX=0.2n
.param LP1=26n LP2=26n LP3=20n LP4=20n K12=0.6 K13=0.1 K14=0.15 K23=0.1 K24=0.15 K34=0
.param LESL=10n LSHUNT=2n LBULK=21.519n RG=3.9 ROL=0.55 ROH=5 VDRV=15 CSNUB=1n
.param C38=0.1u C39=0.1u CBULK=5.4u
.param ROFF=1.34482758621 CGS=1n RDPX=7.44e-05
.include params.inc
.options itl4=100000
.temp {TJ}
.param GL0={VDRV*(1-DIR)} GL1={VDRV*DIR}
.param GH0={VDRV*DIR} GH1={VDRV*(1-DIR)}
.param TLS={T1+DIR*DT} THS={T1+(1-DIR)*DT}
.param ILOAD_SIGNED={IL*(1-2*DIR)}

* ---- DC bus: bulk path (not FEM) and the two local film capacitors
Vbus src 0 {VBUS}
Rsrc src bulk 10m
Cbulk bulk 0 {CBULK}
Lbulk bulk bus {LBULK}
L_P1 bus c38a {LP1}
Lesl38 c38a c38b {LESL}
Rc38 c38b c38c 5m
Cc38 c38c 0 {C38}
L_P2 bus c39a {LP2}
Lesl39 c39a c39b {LESL}
Rc39 c39b c39c 5m
Cc39 c39c 0 {C39}

* ---- power path: bus -> HS -> sw -> LS -> shunt -> 0 (board L is in L_P1/L_P2)
XQH bus g_hs sw IPW65R018CFD7_TT
Vids sw d_ls 0
XQL d_ls g_ls s_ls IPW65R018CFD7_TT
Lshunt s_ls shunt {LSHUNT}
Rshunt shunt 0 1m
Csnh bus sw {CSNUB}
Csnl d_ls s_ls {CSNUB}

* ---- load (ramped from 0 for a consistent operating point)
Iload bus sw PWL(0 0 1u {ILOAD_SIGNED})

* ---- drivers: output-resistance approximation (round 3), then the gate
* resistor, then the board gate-loop inductor (first node at the gate)
Vgl_cmd gl_cmd s_ls PULSE({GL0} {GL1} {TLS} 5n 5n 10u 20u)
Bgl gdl s_ls I={(v(gdl,s_ls)-(-1.6))*(1-v(gl_cmd,s_ls)/VDRV)/ROL+(v(gdl,s_ls)-VDRV)*v(gl_cmd,s_ls)/(VDRV*ROH)}
Rgl gdl gdl3 {RG}
L_P4 g_ls gdl3 {LP4}
Rholdl g_ls s_ls 10k
Vgh_cmd gh_cmd sw PULSE({GH0} {GH1} {THS} 5n 5n 10u 20u)
Bgh gdh sw I={(v(gdh,sw)-(-1.6))*(1-v(gh_cmd,sw)/VDRV)/ROL+(v(gdh,sw)-VDRV)*v(gh_cmd,sw)/(VDRV*ROH)}
Rgh gdh gdh3 {RG}
L_P3 g_hs gdh3 {LP3}
Rholdh g_hs sw 10k

* ---- FEM couplings
K12 L_P1 L_P2 {K12}
K13 L_P1 L_P3 {K13}
K14 L_P1 L_P4 {K14}
K23 L_P2 L_P3 {K23}
K24 L_P2 L_P4 {K24}
K34 L_P3 L_P4 {K34}

.tran {TRMAX} {T1+DT+0.8u} 0 {TRMAX}
.save v(sw) v(bus) v(xql.dd) v(xql.g) v(xql.s) v(xqh.dd) v(xqh.g) v(xqh.s) v(gl_cmd) v(gh_cmd) i(vids)

.meas tran vds_ls_die_pk MAX par('v(xql.dd)-v(xql.s)') from={T1} to={T1+DT+0.75u}
.meas tran vds_hs_die_pk MAX par('v(xqh.dd)-v(xqh.s)') from={T1} to={T1+DT+0.75u}
.meas tran vgs_ls_die_max MAX par('v(xql.g)-v(xql.s)') from={T1} to={T1+DT+0.75u}
.meas tran vgs_ls_die_min MIN par('v(xql.g)-v(xql.s)') from={T1} to={T1+DT+0.75u}
.meas tran vgs_hs_die_max MAX par('v(xqh.g)-v(xqh.s)') from={T1} to={T1+DT+0.75u}
.meas tran vgs_hs_die_min MIN par('v(xqh.g)-v(xqh.s)') from={T1} to={T1+DT+0.75u}
* Off-device gate during the partner's turn-on (false turn-on check): the
* device turned off at T1 (LS for DIR=0, HS for DIR=1), from the partner's
* on command to the end of the window.
.meas tran vgs_ls_off_max MAX par('v(xql.g)-v(xql.s)') from={T1+DT} to={T1+DT+0.75u}
.meas tran vgs_hs_off_max MAX par('v(xqh.g)-v(xqh.s)') from={T1+DT} to={T1+DT+0.75u}
* Incoming device's die VDS at its own on command (ZVS check: ~0 V means
* the load current already discharged it): HS at THS for DIR=0, LS at TLS for
* DIR=1 (each measured for both directions; the runner picks the right one).
.meas tran vds_hs_at_on FIND par('v(xqh.dd)-v(xqh.s)') AT={THS}
.meas tran vds_ls_at_on FIND par('v(xql.dd)-v(xql.s)') AT={TLS}
* Turned-off device's die VGS at the partner's on command (T1+DT): above
* threshold there means the dead time was too short (shoot-through risk), as
* opposed to a later rebound (false turn-on).
.meas tran vgs_ls_at_partner FIND par('v(xql.g)-v(xql.s)') AT={T1+DT}
.meas tran vgs_hs_at_partner FIND par('v(xqh.g)-v(xqh.s)') AT={T1+DT}
* D6 off1_c1_neg2: generic proposed remedy; no layout added.
.include /Users/bennet/Desktop/temper/worktrees/ps-integrate/zapote/power-stage-120v/validation-plan/sim-kit/models/vendor/PMEG6030EP.txt
XDoffl gdl3 offl PMEG6030EP
Roffl offl gdl {ROFF}
XDoffh gdh3 offh PMEG6030EP
Roffh offh gdh {ROFF}
Cgsl g_ls s_ls {CGS}
Cgsh g_hs sw {CGS}
.meas tran e_l_pre INTEG par('max(0,(v(xql.dd)-v(xql.s))*(v(xql.ldrd)-v(xql.dd))/7.44e-5)') from={T1} to={T1+DT}
.meas tran e_l_post INTEG par('max(0,(v(xql.dd)-v(xql.s))*(v(xql.ldrd)-v(xql.dd))/7.44e-5)') from={T1+DT} to={T1+DT+0.75u}
.meas tran e_h_pre INTEG par('max(0,(v(xqh.dd)-v(xqh.s))*(v(xqh.ldrd)-v(xqh.dd))/7.44e-5)') from={T1} to={T1+DT}
.meas tran e_h_post INTEG par('max(0,(v(xqh.dd)-v(xqh.s))*(v(xqh.ldrd)-v(xqh.dd))/7.44e-5)') from={T1+DT} to={T1+DT+0.75u}

* ---- c33 adoption: board switch-node capacitance (plane-pair screen) and the ZVS crossing time
Cbrd_ret sw 0 {CBRD_RET}
Cbrd_bus sw bus {CBRD_BUS}
.meas tran t_hs_zvs WHEN par('v(xqh.dd)-v(xqh.s)')={0.05*VBUS} FALL=1 TD={T1}
.meas tran t_ls_zvs WHEN par('v(xql.dd)-v(xql.s)')={0.05*VBUS} FALL=1 TD={T1}

* ---- c25 dv/dt probes (measurement only; V/ns)
Bdvsw dvsw 0 V={ddt(v(sw))*1e-9}
Bdvls dvls 0 V={ddt(v(xql.dd)-v(xql.s))*1e-9}
Bdvhs dvhs 0 V={ddt(v(xqh.dd)-v(xqh.s))*1e-9}
.meas tran dvsw_max MAX v(dvsw) from={T1} to={T1+DT+0.75u}
.meas tran dvsw_min MIN v(dvsw) from={T1} to={T1+DT+0.75u}
.meas tran dvls_max MAX v(dvls) from={T1} to={T1+DT+0.75u}
.meas tran dvls_min MIN v(dvls) from={T1} to={T1+DT+0.75u}
.meas tran dvhs_max MAX v(dvhs) from={T1} to={T1+DT+0.75u}
.meas tran dvhs_min MIN v(dvhs) from={T1} to={T1+DT+0.75u}
* 20-80 % switch-node edge time (board node sw vs leg return), first crossing after T1
.meas tran tr2080 TRIG v(sw) VAL={0.2*VBUS} RISE=1 TD={T1} TARG v(sw) VAL={0.8*VBUS} RISE=1 TD={T1}
.meas tran tf8020 TRIG v(sw) VAL={0.8*VBUS} FALL=1 TD={T1} TARG v(sw) VAL={0.2*VBUS} FALL=1 TD={T1}
.meas tran tr1090 TRIG v(sw) VAL={0.1*VBUS} RISE=1 TD={T1} TARG v(sw) VAL={0.9*VBUS} RISE=1 TD={T1}
.meas tran tf9010 TRIG v(sw) VAL={0.9*VBUS} FALL=1 TD={T1} TARG v(sw) VAL={0.1*VBUS} FALL=1 TD={T1}

* ---- device study: window and gate-loop charge (post-processing .meas only; no added elements)
.param TW0={T1-20n} TW1={T1+DT+0.75u}
.save i(l_p3) i(l_p4)
* gate-loop charge (L_P3/L_P4 carry the whole gate current incl. the 1 nF Cgs and the PMEG branch; + = gate discharge)
.meas tran qh_win INTEG i(l_p3) from={TW0} to={TW1}
.meas tran ql_win INTEG i(l_p4) from={TW0} to={TW1}

* ---- device study: die heat (vendor heat channels, signed) over the transition window
Bphs phs 0 V={(v(xqh.x1.d)-v(xqh.s))*i(v.xqh.x1.v_ichannel)+(v(xqh.dd)-v(xqh.x1.d1))*i(v.xqh.x1.v_iepi)+(v(xqh.dd)-v(xqh.s))*i(v.xqh.x1.v_sense2)}
Bpls pls 0 V={(v(xql.x1.d)-v(xql.s))*i(v.xql.x1.v_ichannel)+(v(xql.dd)-v(xql.x1.d1))*i(v.xql.x1.v_iepi)+(v(xql.dd)-v(xql.s))*i(v.xql.x1.v_sense2)}
.save v(phs) v(pls)
.meas tran e_hs_die INTEG v(phs) from={TW0} to={TW1}
.meas tran e_ls_die INTEG v(pls) from={TW0} to={TW1}
.meas tran p_hs_end FIND v(phs) AT={TW1-5n}
.meas tran p_ls_end FIND v(pls) AT={TW1-5n}
.meas tran p_hs_start FIND v(phs) AT={TW0}
.meas tran p_ls_start FIND v(pls) AT={TW0}

* ---- gate-network study: commutated-diode current (die drain current, + into drain) and edge measures
.save v(xql.ldrd) v(xqh.ldrd) v(xql.dd) v(xqh.dd) v(g_ls) v(g_hs) v(gdl3) v(gdh3)
.param IABS={abs(IL)+1e-3}
.meas tran ild_min MIN par('(v(xql.ldrd)-v(xql.dd))/RDPX') from={T1} to={T1+DT+0.75u}
.meas tran ild_max MAX par('(v(xql.ldrd)-v(xql.dd))/RDPX') from={T1+DT} to={T1+DT+0.75u}
.meas tran ihd_min MIN par('(v(xqh.ldrd)-v(xqh.dd))/RDPX') from={T1} to={T1+DT+0.75u}
.meas tran ihd_max MAX par('(v(xqh.ldrd)-v(xqh.dd))/RDPX') from={T1+DT} to={T1+DT+0.75u}
.meas tran tl75 WHEN par('(v(xql.ldrd)-v(xql.dd))/RDPX')={-0.75*IABS} RISE=1 TD={T1+DT}
.meas tran tl50 WHEN par('(v(xql.ldrd)-v(xql.dd))/RDPX')={-0.50*IABS} RISE=1 TD={T1+DT}
.meas tran tl25 WHEN par('(v(xql.ldrd)-v(xql.dd))/RDPX')={-0.25*IABS} RISE=1 TD={T1+DT}
.meas tran tl00 WHEN par('(v(xql.ldrd)-v(xql.dd))/RDPX')=0 RISE=1 TD={T1+DT}
.meas tran th75 WHEN par('(v(xqh.ldrd)-v(xqh.dd))/RDPX')={-0.75*IABS} RISE=1 TD={T1+DT}
.meas tran th50 WHEN par('(v(xqh.ldrd)-v(xqh.dd))/RDPX')={-0.50*IABS} RISE=1 TD={T1+DT}
.meas tran th25 WHEN par('(v(xqh.ldrd)-v(xqh.dd))/RDPX')={-0.25*IABS} RISE=1 TD={T1+DT}
.meas tran th00 WHEN par('(v(xqh.ldrd)-v(xqh.dd))/RDPX')=0 RISE=1 TD={T1+DT}
* energy dissipated in the series gate resistors (R_on) and the turn-off branch resistors over the window
.save v(gdl) v(gdh) v(offl) v(offh)
.meas tran e_rgl INTEG par('(v(gdl)-v(gdl3))*(v(gdl)-v(gdl3))/RG') from={T1-20n} to={T1+DT+0.75u}
.meas tran e_rgh INTEG par('(v(gdh)-v(gdh3))*(v(gdh)-v(gdh3))/RG') from={T1-20n} to={T1+DT+0.75u}
* incoming gate (die) reaching 4 V / 10 V after its on command (turn-on delay, plateau exit)
.meas tran tgh4 WHEN par('v(xqh.g)-v(xqh.s)')=4 RISE=1 TD={THS}
.meas tran tgl4 WHEN par('v(xql.g)-v(xql.s)')=4 RISE=1 TD={TLS}
.meas tran tgh10 WHEN par('v(xqh.g)-v(xqh.s)')=10 RISE=1 TD={THS}
.meas tran tgl10 WHEN par('v(xql.g)-v(xql.s)')=10 RISE=1 TD={TLS}
.end
