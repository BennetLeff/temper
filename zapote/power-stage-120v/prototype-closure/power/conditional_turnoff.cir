* CONDITIONAL D17 COMMUTATION SENSITIVITY, derived from Round 17 D2: complementary half-bridge leg with the FEM board inductance
* matrix as four coupled inductors (one per FEM port), one transition.
* Built from round 3's complementary_leg.cir (same driver approximation,
* Infineon L1 models, snubbers, shunt, load, solver options).
*
* Board copper: the 4x4 FEM matrix (h -> 0) maps onto
*   L_P1  in series with C38's branch   (port P1: C38.1 bus_p -> C38.2 hv_ret)
*   L_P2  in series with C39's branch   (port P2: C39.1 bus_p -> C39.2 hv_ret)
*   L_P3  in the high-side gate path    (port P3: driver out_h -> sw, i.e. +
*         is gate-discharge current, gate -> driver)
*   L_P4  in the low-side gate path     (port P4: driver out_l -> leg_ret)
* coupled by K (k_ij = L_ij/sqrt(L_ii L_jj)). Each inductor's first node is
* the end where FEM port current enters (the port's 'a' side), so the K
* signs carry over. The FEM shorted the FETs, gate resistors and shunt at
* their pads (closures), so those parts sit in the SPICE loops at the same
* places; the FEM ports were at the capacitors and the driver pins.
* The common-source effect is the P1/P2-to-P3/P4 coupling (no separate LCS).
*
* NOT from the FEM: LBULK (bulk-capacitor path, round-3 heuristic copper
* value), capacitor ESL LESL (TDK bound <= ~20 nH, PACKAGE-INDUCTANCE.md),
* shunt inductance LSHUNT (Vishay 0.5-5 nH). The Infineon L1 subcircuit
* already contains the TO-247 leads (Ld 1.88, Ls 2.82, Lg 8.32 nH) and
* Rg,int 2.7 ohm: do not add package L again.

.include IFX_CFD7_650V.lib
.include ../common/options.inc
* D-14 (delegation/out-D14): raise the transient iteration limit; resolves
* the 'timestep too small' aborts without changing converged results.
.options itl4=100000

* ---- defaults; params.inc (written by the runner) overrides them
.param VBUS=170 IL=37 DIR=0 T1=2u DT=348n TRMAX=0.2n
.param ITRIP=60.014 SLOPE=10e6 TD=1u
.param TCMD={T1+TD}
.param LP1=26n LP2=26n LP3=20n LP4=20n K12=0.6 K13=0.1 K14=0.15 K23=0.1 K24=0.15 K34=0
.param LESL=10n LSHUNT=2n LBULK=21.519n RG=3.9 ROL=0.55 ROH=5 VDRV=15 CSNUB=1n
.param C38=0.1u C39=0.1u CBULK=5.4u
.include params.inc
.param GL0={VDRV*(1-DIR)} GL1={VDRV*DIR}
.param GH0={VDRV*DIR} GH1={VDRV*(1-DIR)}
.param TLS={T1+DIR*DT} THS={T1+(1-DIR)*DT}
.param ILOAD_SIGNED={IL*(1-2*DIR)}

* ---- DC bus: bulk path (not FEM) and the two local film capacitors
Vbus src 0 {VBUS}
Rsrc src bulk 10m
Cbulk bulk 0 {CBULK}
Lbulk bulk bus {LBULK}
L_P1 bus c38a {LP1}
Lesl38 c38a c38b {LESL}
Rc38 c38b c38c 5m
Cc38 c38c 0 {C38}
L_P2 bus c39a {LP2}
Lesl39 c39a c39b {LESL}
Rc39 c39b c39c 5m
Cc39 c39c 0 {C39}

* ---- power path: bus -> HS -> sw -> LS -> shunt -> 0 (board L is in L_P1/L_P2)
XQH bus g_hs sw IPW65R018CFD7_L1
Vids sw d_ls 0
XQL d_ls g_ls s_ls IPW65R018CFD7_L1
Lshunt s_ls shunt {LSHUNT}
Rshunt shunt 0 1m
Csnh bus sw {CSNUB}
Csnl d_ls s_ls {CSNUB}

* ---- load (ramped from 0 for a consistent operating point)
* Imposed current, not a physical tank or short circuit.
Bload bus sw I={if(time<1u,ITRIP*time/1u,ITRIP+SLOPE*max(time-T1,0))}

* ---- drivers: output-resistance approximation (round 3), then the gate
* resistor, then the board gate-loop inductor (first node at the gate)
Vgl_cmd gl_cmd s_ls PULSE({VDRV} 0 {TCMD} 5n 5n 10u 20u)
Bgl gdl s_ls I={v(gdl,s_ls)*(1-v(gl_cmd,s_ls)/VDRV)/ROL+(v(gdl,s_ls)-VDRV)*v(gl_cmd,s_ls)/(VDRV*ROH)}
Rgl gdl gdl3 {RG}
L_P4 g_ls gdl3 {LP4}
Rholdl g_ls s_ls 10k
Vgh_cmd gh_cmd sw 0
Bgh gdh sw I={v(gdh,sw)*(1-v(gh_cmd,sw)/VDRV)/ROL+(v(gdh,sw)-VDRV)*v(gh_cmd,sw)/(VDRV*ROH)}
Rgh gdh gdh3 {RG}
L_P3 g_hs gdh3 {LP3}
Rholdh g_hs sw 10k

* ---- FEM couplings
K12 L_P1 L_P2 {K12}
K13 L_P1 L_P3 {K13}
K14 L_P1 L_P4 {K14}
K23 L_P2 L_P3 {K23}
K24 L_P2 L_P4 {K24}
K34 L_P3 L_P4 {K34}

* The command delay is swept; comparator, isolator, interlock and DIS are
* not modeled here. Neither gate crossing nor this forced current model
* establishes current extinction, device energy/SOA or returned bus energy.
.tran {TRMAX} {TCMD+0.8u} 0 {TRMAX}
.meas tran gate_first_1p9 WHEN par('v(xql.g)-v(xql.s)')=1.9 FALL=1
.meas tran imposed_current_at_first_1p9 PARAM='ITRIP+SLOPE*(gate_first_1p9-T1)'
.meas tran vds_ls_die_pk MAX par('v(xql.dd)-v(xql.s)') from={TCMD} to={TCMD+0.75u}
.meas tran vds_hs_die_pk MAX par('v(xqh.dd)-v(xqh.s)') from={TCMD} to={TCMD+0.75u}
.meas tran vgs_hs_off_max MAX par('v(xqh.g)-v(xqh.s)') from={TCMD} to={TCMD+0.75u}
.meas tran vgs_ls_late_max MAX par('v(xql.g)-v(xql.s)') from={TCMD+0.4u} to={TCMD+0.75u}
.meas tran vgs_ls_min MIN par('v(xql.g)-v(xql.s)') from={TCMD} to={TCMD+0.75u}
.end
