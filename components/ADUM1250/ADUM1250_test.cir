* ADUM1250 Test Circuit for Induction Cooker Application
* I2C Isolation Between Microcontroller and High-Voltage Side Sensors
* This netlist demonstrates the ADUM1250 isolating I2C communication
* Suitable for ngspice simulation

.title ADUM1250 I2C Isolator Test Circuit

* Include the ADUM1250 model
.include ADUM1250.lib

***************************************************************************
* Power Supplies
***************************************************************************
* Side 1: Microcontroller side (low-voltage logic)
VDD1 VDD1 0 DC 3.3

* Side 2: Isolated high-voltage side sensors
VDD2 VDD2 0 DC 5.0

***************************************************************************
* ADUM1250 I2C Isolator
***************************************************************************
XISO VDD1 SCL1 SDA1 0 0 SDA2 SCL2 VDD2 ADUM1250

***************************************************************************
* Side 1: Microcontroller I2C Master (Low-Voltage Side)
***************************************************************************
* Pull-up resistors for Side 1 I2C bus
R_PU_SCL1 VDD1 SCL1 4.7k
R_PU_SDA1 VDD1 SDA1 4.7k

* Bus capacitance
C_BUS_SCL1 SCL1 0 50p
C_BUS_SDA1 SDA1 0 50p

***************************************************************************
* I2C Transaction Simulation - Side 1 (Master)
***************************************************************************
* SCL (Clock) generation - 100kHz I2C
* START condition at t=50us (SDA falls)
* SCL stays High initially.
* First clock pulse starts around 50-55us?
* Standard: Start = SDA Fall while SCL High. Then SCL Fall.
* Let's drop SCL at 50us.
* Pulse: 1->0 at 50us. Low for 5us. High for 5us. Period 10us.
V_SCL1_CTRL N_SCL1_CTRL 0 PULSE(1 0 50u 100n 100n 5u 10u)

S_SCL1_DRV SCL1 0 N_SCL1_CTRL 0 SCL_SW
R_SCL1_DRV_ON SCL1 0 1

* SDA (Data) generation - PWL
* Address 0x48 (0100 1000) Write (0) -> 0100 1000 0
* 0: Idle High
* 48u: Start (Fall) -> 0
* 50u: SCL Fall (Bit 7 Setup) - Bit 7 is 0. Stay 0.
* 60u: SCL Fall (Bit 6 Setup) - Bit 6 is 1. Rise to 1 at 61u.
* 70u: SCL Fall (Bit 5 Setup) - Bit 5 is 0. Fall to 0 at 71u.
* 80u: SCL Fall (Bit 4 Setup) - Bit 4 is 0. Stay 0.
* 90u: SCL Fall (Bit 3 Setup) - Bit 3 is 1. Rise to 1 at 91u.
* 100u: SCL Fall (Bit 2 Setup) - Bit 2 is 0. Fall to 0 at 101u.
* 110u: SCL Fall (Bit 1 Setup) - Bit 1 is 0. Stay 0.
* 120u: SCL Fall (Bit 0 Setup) - Bit 0 is 0 (Write). Stay 0.
* 130u: SCL Fall (ACK Setup) - Master releases SDA (High). Rise at 131u.
* Slave should pull low for ACK.
V_SDA1_CTRL N_SDA1_CTRL 0 PWL(
+ 0 1
+ 48u 1 48.1u 0
+ 61u 0 61.1u 1
+ 71u 1 71.1u 0
+ 91u 0 91.1u 1
+ 101u 1 101.1u 0
+ 131u 0 131.1u 1
+ )

S_SDA1_DRV SDA1 0 N_SDA1_CTRL 0 SDA_SW
R_SDA1_DRV_ON SDA1 0 1

* Model for open-drain drivers
.model SCL_SW SW(Ron=10 Roff=100Meg Vt=0.5 Vh=0.0)
.model SDA_SW SW(Ron=10 Roff=100Meg Vt=0.5 Vh=0.0)

***************************************************************************
* Side 2: I2C Slave Device (High-Voltage Isolated Side)
***************************************************************************
R_PU_SCL2 VDD2 SCL2 2.2k
R_PU_SDA2 VDD2 SDA2 2.2k
C_BUS_SCL2 SCL2 0 100p
C_BUS_SDA2 SDA2 0 100p

***************************************************************************
* I2C Slave Response Simulation - Side 2
***************************************************************************
* Slave ACK: Pull SDA low during 9th clock pulse (135us High period)
* SCL High: 135u-140u.
* Slave should pull low from 132u to 142u approx.
V_SDA2_SLAVE_CTRL N_SDA2_SLAVE_CTRL 0 PWL(
+ 0 0
+ 132u 0 132.1u 1
+ 142u 1 142.1u 0
+ )

S_SDA2_SLAVE SDA2 0 N_SDA2_SLAVE_CTRL 0 SDA2_SLAVE_SW
R_SDA2_SLAVE_ON SDA2 0 1
.model SDA2_SLAVE_SW SW(Ron=20 Roff=100Meg Vt=0.5 Vh=0.0)

C_SLAVE_SCL SCL2 0 20p
C_SLAVE_SDA SDA2 0 20p

***************************************************************************
* Power Supply Decoupling
***************************************************************************
C_BYP1_100n VDD1 0 100n
C_BYP1_10u VDD1 0 10u IC=3.3
C_BYP2_100n VDD2 0 100n
C_BYP2_10u VDD2 0 10u IC=5.0

***************************************************************************
* Measurement Points
***************************************************************************
V_SENSE_IDD1 VDD1 N_VDD1_LOCAL 0
V_SENSE_IDD2 VDD2 N_VDD2_LOCAL 0
R_VDD1_LOCAL N_VDD1_LOCAL VDD1 0.001
R_VDD2_LOCAL N_VDD2_LOCAL VDD2 0.001

***************************************************************************
* Simulation Control
***************************************************************************
.tran 100n 200u 0 100n
.ic V(SCL1)=3.3 V(SDA1)=3.3 V(SCL2)=5.0 V(SDA2)=5.0
.ic V(VDD1)=3.3 V(VDD2)=5.0

.options gmin=1e-12 abstol=1e-10 reltol=0.001 method=gear

***************************************************************************
* Output Control
***************************************************************************
.save V(VDD1) V(VDD2) V(SCL1) V(SDA1) V(SCL2) V(SDA2) I(V_SENSE_IDD1) I(V_SENSE_IDD2)

.control
run
set hcopydevtype=postscript
set color0=white
set color1=black

echo "===== ADUM1250 I2C Isolator Test Results ====="

meas tran i_dd1_avg AVG I(V_SENSE_IDD1) FROM=100u TO=200u
meas tran i_dd2_avg AVG I(V_SENSE_IDD2) FROM=100u TO=200u
print i_dd1_avg i_dd2_avg

meas tran prop_delay_scl_1to2 TRIG V(SCL1) VAL=1.65 FALL=1 TARG V(SCL2) VAL=2.5 FALL=1
print prop_delay_scl_1to2

meas tran prop_delay_sda_1to2 TRIG V(SDA1) VAL=1.65 FALL=1 TARG V(SDA2) VAL=2.5 FALL=1
print prop_delay_sda_1to2

echo "Simulation Complete"
.endc
.end
