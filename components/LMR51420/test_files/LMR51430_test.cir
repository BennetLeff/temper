*******************************************************************************
* LMR51430 Test Circuit - Simple 12V to 5V Buck
*******************************************************************************

.TITLE LMR51430 Buck Converter Test

.INCLUDE LMR51430.lib

*------------------------------------------------------------------------------
* Options for stable simulation
*------------------------------------------------------------------------------
.OPTIONS RELTOL=0.001 ABSTOL=1N VNTOL=1M
.OPTIONS ITL1=300 ITL4=50
.OPTIONS METHOD=TRAP

*------------------------------------------------------------------------------
* 12V Input (ramped for convergence)
*------------------------------------------------------------------------------
VIN VIN 0 PWL(0 0 50U 12 100M 12)

*------------------------------------------------------------------------------
* Input Cap
*------------------------------------------------------------------------------
CIN VIN 0 10U IC=0

*------------------------------------------------------------------------------
* Enable tied to VIN
*------------------------------------------------------------------------------
REN VIN EN 10K
CEN EN 0 10N IC=0

*------------------------------------------------------------------------------
* Buck Converter
*------------------------------------------------------------------------------
XU1 VIN 0 EN SW FB CB LMR51430X

*------------------------------------------------------------------------------
* Bootstrap Cap
*------------------------------------------------------------------------------
CBOOT CB SW 100N IC=0

*------------------------------------------------------------------------------
* Output LC Filter
*------------------------------------------------------------------------------
L1 SW VOUT 6.8U IC=0
COUT VOUT 0 44U IC=0

*------------------------------------------------------------------------------
* Feedback Divider (5V output)
* VOUT = 0.6 * (1 + 100k/13.7k) = 4.98V
*------------------------------------------------------------------------------
RFBT VOUT FB 100K
RFBB FB 0 13.7K

*------------------------------------------------------------------------------
* Load: 2.5 ohm = 2A at 5V
*------------------------------------------------------------------------------
RLOAD VOUT 0 2.5

*------------------------------------------------------------------------------
* Analysis
*------------------------------------------------------------------------------
.TRAN 100N 15M 0 100N UIC

*------------------------------------------------------------------------------
* Measurements
*------------------------------------------------------------------------------
.MEAS TRAN VOUT_AVG AVG V(VOUT) FROM=8M TO=10M
.MEAS TRAN VOUT_PP PP V(VOUT) FROM=9M TO=9.5M
.MEAS TRAN IL_AVG AVG I(L1) FROM=8M TO=10M
.MEAS TRAN TSTART WHEN V(VOUT)=4.5 RISE=1

*------------------------------------------------------------------------------
* Control Script
*------------------------------------------------------------------------------
.CONTROL

set filetype=ascii
set color0=white
set color1=red
set color2=blue
set color3=green

echo ""
echo "===================================="
echo "  LMR51430 Buck Converter Test"
echo "===================================="

run

echo "Done! Plotting results..."

* Main plots
plot v(vout) title "Output Voltage" ylabel "V"
plot v(sw) title "Switch Node" ylabel "V"
plot i(l1) title "Inductor Current" ylabel "A"

* Detail plots
plot v(sw) xlimit 25m 25.02m title "SW Detail (steady state)"
plot i(l1) xlimit 25m 25.02m title "IL Detail"

* Control signals
plot v(en) v(fb) xu1.enable xu1.ea xu1.pwm title "Control Signals"

echo ""
echo "===================================="
echo "RESULTS:"
echo "===================================="
print vout_avg vout_pp il_avg tstart
echo "===================================="
echo ""
echo "Expected: VOUT ~ 5V, IL ~ 2A"
echo ""

.ENDC

.END
