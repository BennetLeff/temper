* IKW40N120H3 Test Circuit for Induction Cooker Application
* Half-Bridge Resonant Inverter with UCC21550 Gate Driver
* This netlist demonstrates the IKW40N120H3 IGBT in a complete induction cooker circuit
* Suitable for ngspice simulation

.title IKW40N120H3 Induction Cooker Test Circuit

* Include the IGBT and Gate Driver models
.include IKW40N120H3.lib
.include ../UCC21550/UCC21550.lib

***************************************************************************
* Power Supplies
***************************************************************************
* Rectified AC mains (300V DC bus)
VDC_BUS VDC 0 DC 300

* Gate driver supply (15V for IGBT gate drive)
* Low Side Supply (Referenced to Ground)
VDD_LS VDDB 0 DC 15.0

* High Side Supply (Floating, Referenced to SW Node)
* This simulates the isolated supply or bootstrap capacitor
VDD_HS VDDA SW DC 15.0

* Primary side logic supply (5V)
VCC VCCI 0 DC 5.0

***************************************************************************
* Input PWM Signals from Microcontroller
***************************************************************************
* Operating frequency: 50kHz (20us period)
* Dead time: 1us
* Duty cycle: 45% each (9us on, 11us off including dead time)

* High-side input
VIN_HS INA 0 PULSE(0 3.3 0 10n 10n 9u 20u)

* Low-side input (Phase shifted)
* Start at 10us (180 deg phase shift)
VIN_LS INB 0 PULSE(0 3.3 10u 10n 10n 9u 20u)

* Disable input
VDIS DIS 0 DC 0

***************************************************************************
* UCC21550A Isolated Gate Driver
***************************************************************************
XUCC21550 INA INB VCCI 0 DIS DT_PIN NC1 VCCI 0 GATE_LS VDDB NC2 NC3 SW GATE_HS VDDA UCC21550A

R_DT DT_PIN 0 1MEG

***************************************************************************
* Gate Drive Circuits
***************************************************************************
* High-side gate drive
R_G_HS GATE_HS N_G_HS 3.3
L_G_HS N_G_HS HS_GATE 10n
R_GS_HS HS_GATE SW 10k

* Low-side gate drive
R_G_LS GATE_LS N_G_LS 3.3
L_G_LS N_G_LS LS_GATE 10n
R_GS_LS LS_GATE 0 10k

***************************************************************************
* High-Side IGBT (IKW40N120H3)
***************************************************************************
XQ_HS VDC HS_GATE SW IKW40N120H3
C_GE_HS HS_GATE SW 1n

***************************************************************************
* Low-Side IGBT (IKW40N120H3)
***************************************************************************
XQ_LS SW LS_GATE 0 IKW40N120H3
C_GE_LS LS_GATE 0 1n

***************************************************************************
* DC Bus Decoupling and Snubber
***************************************************************************
C_BUS_ELEC VDC 0 100u IC=300
R_BUS_ESR VDC N_BUS 0.05
C_BUS_FILM N_BUS 0 2.2u

R_SNUB_HS VDC N_SNUB_HS 47
C_SNUB_HS N_SNUB_HS SW 22n

R_SNUB_LS SW N_SNUB_LS 47
C_SNUB_LS N_SNUB_LS 0 22n

***************************************************************************
* Resonant Load (Induction Coil)
***************************************************************************
* Series resonant LC
* L=100uH, C=0.22uF -> f0=34kHz
* Driving at 50kHz (Inductive region, ZVS)

C_RES SW N_COIL 0.22u IC=0
L_COIL N_COIL N_LOAD 100u IC=0
R_COIL N_LOAD LOAD 0.3
R_LOAD LOAD 0 0.2
C_COIL_PAR N_COIL 0 20p

***************************************************************************
* Parasitic Elements
***************************************************************************
L_BUS_P VDC N_VDC_LOCAL 20n
L_BUS_N 0 N_GND_LOCAL 20n
R_BUS_P N_VDC_LOCAL VDC 0.001
R_BUS_N N_GND_LOCAL 0 0.001

***************************************************************************
* Measurement Points
***************************************************************************
V_SENSE_DC N_VDC_LOCAL VDC 0
V_SENSE_LOAD LOAD N_LOAD_SENSE 0
R_LOAD_SENSE N_LOAD_SENSE 0 0.001

***************************************************************************
* Simulation Control
***************************************************************************
* Run for 200us (10 cycles)
.tran 10n 200u 0 10n

* Initial conditions
.ic V(SW)=0 V(VDC)=300 V(HS_GATE)=0 V(LS_GATE)=0

.options gmin=1e-12 abstol=1e-9 reltol=0.001 method=gear

***************************************************************************
* Output Control
***************************************************************************
.save V(INA) V(INB) V(GATE_HS) V(GATE_LS) V(HS_GATE) V(LS_GATE)
.save V(SW) V(N_COIL) V(LOAD)
.save I(L_COIL) I(V_SENSE_DC) I(V_SENSE_LOAD)

* Print results
.control
run
set hcopydevtype=postscript
set color0=white
set color1=black

echo "===== IKW40N120H3 Induction Cooker Test Results ====="

* Measure switching node voltage
meas tran v_sw_max MAX V(SW) FROM=100u TO=120u
print v_sw_max

* Measure Peak Coil Current
meas tran i_coil_peak MAX I(L_COIL) FROM=100u TO=200u
print i_coil_peak

* Measure Power
let p_load = v(load) * i(v_sense_load)
meas tran p_load_avg AVG p_load FROM=100u TO=200u
print p_load_avg

.endc
.end
