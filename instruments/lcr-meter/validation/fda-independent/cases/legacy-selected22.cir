Independent FDA internal control cut; legacy-selected22
.include ../legacy-probe.lib
.options reltol=1e-5 abstol=1e-12 vntol=1e-7
V5 vp 0 5
Vcm cm 0 2.048
Vin inp 0 0
Rin1 inp ip 1000
Rin2 0 im 1000
Rout1 om fbm 22
Rout2 op fbp 22
Rfb1 fbm ip 1000
Rfb2 fbp im 1000
Cfb1 fbm ip 0.0000000001
Cfb2 fbp im 0.0000000001
X1 om op cm im ip 0 vp vp THS4551
Riso1 fbp ap 4.32
Riso2 fbm am 4.32
Cflt1 ap 0 0.00000000033
Cflt2 am 0 0.00000000033
Cdiff ap am 0.0000000033
Cadc1 ap 0 16p
Cadc2 am 0 16p
.control
set klu
set wr_singlescale
set wr_vecnames
set numdgt=17
op
print v(op) v(om)
ac dec 120 1 1G
let returned=v(x1.xi0.xi0.vinp_int)-v(x1.xi0.xi0.vinm_int)
let forward=v(x1.xi0.xi0.vinp_int_probe)-v(x1.xi0.xi0.vinm_int)
let loop=-returned/forward
wrdata legacy-selected22.dat real(loop) imag(loop)
quit
.endc
.end
