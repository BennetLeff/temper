RevC exact full chain; official models; real FDA bias and ADC RC loads
.include models/opa2810_a.lib
.include models/opa810_a.lib
.include models/ths4551.lib
.options reltol=1e-5 abstol=1e-12 vntol=1e-7 method=gear
.include final-seed.inc
RDUT hi low 100000
Cbadc1 badc_p 0 16p
Cfbb1 bfbm bip 100p
R33 excite srcfb 5k
Rbiso1 bfbp badc_p 4.32
Cadiff aadc_p aadc_m 3.3n
RF low tia 100000
Rdds dds0 dds 200
Vdds dds0 0 DC 0.3 AC 1 SIN(0.3 0.3 50k)
Xb bip bim bop bom cm v5 0 THS4551
Raf2 afbp aim 1k
Cbdiff badc_p badc_m 3.3n
Caadc2 aadc_m 0 16p
RG source hi 100000
Raiso2 afbm aadc_m 4.32
Rbi1 lowbuf bip 1k
Xa aip aim aop aom cm v5 0 THS4551
Cbflt1 badc_p 0 330p
R32 acin 0 100k
Raint2 aop afbp 22
R34 srcfb 0 1k
Cfba2 afbp aim 100p
Rai2 lowbuf aim 1k
C35 lp2 0 1n
Rbf1 bfbm bip 1k
X7B low lowbuf lowbuf vp vn OPA2810
V5 v5 0 5
CF low tia 5p
Rai1 highbuf aip 1k
Raf1 afbm aip 1k
Caflt1 aadc_p 0 330p
Rbiso2 bfbm badc_m 4.32
C36 lp2 acin 1u
C34 lp1 0 1n
R31 lp1 lp2 330
Caadc1 aadc_p 0 16p
Cbflt2 badc_m 0 330p
Vn vn 0 -12
Rbint2 bop bfbp 22
R30 dds lp1 330
X7A 0 low tia vp vn OPA2810
Raiso1 afbp aadc_p 4.32
X5 acin srcfb excite vp vn OPA810
Caflt2 aadc_m 0 330p
Cbadc2 badc_m 0 16p
Rbi2 tia bim 1k
Cfbb2 bfbp bim 100p
X6B hi highbuf highbuf vp vn OPA2810
Cfba1 afbm aip 100p
Vcm cm 0 2.048
Raint1 aom afbm 22
Rbf2 bfbp bim 1k
Vp vp 0 12
Rbint1 bom bfbm 22
X6A excite source source vp vn OPA2810
.control
set klu
set wr_singlescale
set wr_vecnames
set filetype=ascii
op
write revc_100k_resistor-selected_op.raw all
let ihload=(v(highbuf)-v(aip))/1000
let ilload=(v(lowbuf)-v(aim))/1000+(v(lowbuf)-v(bip))/1000
let itload=(v(tia)-v(low))/100000+(v(tia)-v(bim))/1000
let kh=(-i(v.x6b.x_h3.vh_h3))-ihload
let kl=(-i(v.x7b.x_h3.vh_h3))-ilload
let kt=(-i(v.x7a.x_h3.vh_h3))-itload
print v(source) v(hi) v(low) v(tia) v(highbuf) v(lowbuf) v(aip) v(aim) v(bip) v(bim) v(aop) v(aom) v(bop) v(bom) (-i(v.x6b.x_h3.vh_h3)) (-i(v.x7b.x_h3.vh_h3)) (-i(v.x7a.x_h3.vh_h3)) kh kl kt
wrdata revc_100k_resistor-selected_dc.dat v(source) v(hi) v(low) v(tia) v(highbuf) v(lowbuf) v(aip) v(aim) v(bip) v(bim) v(aop) v(aom) v(bop) v(bom) (-i(v.x6b.x_h3.vh_h3)) (-i(v.x7b.x_h3.vh_h3)) (-i(v.x7a.x_h3.vh_h3)) kh kl kt
ac dec 80 10 100Meg
let a=v(aadc_p)-v(aadc_m)
let b=v(badc_p)-v(badc_m)
let ratio=a/b
wrdata revc_100k_resistor-selected_ac.dat real(ratio) imag(ratio) mag(a) mag(b)
tran 10n 120u 0 10n
let a=v(aadc_p)-v(aadc_m)
let b=v(badc_p)-v(badc_m)
wrdata revc_100k_resistor-selected_tran.dat v(dds0) v(source) v(hi) v(low) v(tia) v(highbuf) v(lowbuf) v(aadc_p) v(aadc_m) v(badc_p) v(badc_m) a b
quit
.endc
.end
