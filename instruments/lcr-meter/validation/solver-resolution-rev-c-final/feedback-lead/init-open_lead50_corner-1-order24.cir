RevC exact full chain; official models; real FDA bias and ADC RC loads
.include ../models/opa2810_a.lib
.include ../models/opa810_a.lib
.include ../models/ths4551.lib
.options reltol=1e-5 abstol=1e-12 vntol=1e-7 method=gear
.include ../final-seed.inc
Rbf2 bfbp bim 1k
RF low rf_end 100
Cbdiff badc_p badc_m 3.3n
V5 v5 0 4.75
Cfbb1 bfbm bip 100p
Rai2 lowbuf aim 1k
Xa aip aim aop aom cm v5 0 THS4551
Cbflt2 badc_m 0 330p
X7B low lowbuf lowbuf vp vn OPA2810
Rbi1 lowbuf bip 1k
Lfeedback rf_end tia 50n
R31 lp1 lp2 330
Rbint1 bom bfbm 22
Clo low 0 100p
Rai1 highbuf aip 1k
Vdds dds0 0 DC 0.3 AC 1
Caadc1 aadc_p 0 16p
C35 lp2 0 1n
Cbflt1 badc_p 0 330p
R30 dds lp1 330
Rbint2 bop bfbp 22
Raiso2 afbm aadc_m 4.32
Raint1 aom afbm 22
Vn vn 0 -11.399999999999999
Chi hi 0 100p
Raiso1 afbp aadc_p 4.32
Caflt2 aadc_m 0 330p
CF low rf_end 95p
R33 excite srcfb 5k
Cfbb2 bfbp bim 100p
Rbi2 tia bim 1k
Cfba1 afbm aip 100p
Raf1 afbm aip 1k
X6A excite source source vp vn OPA2810
Caadc2 aadc_m 0 16p
Vcm cm 0 2.048
Cadiff aadc_p aadc_m 3.3n
X5 acin srcfb excite vp vn OPA810
X7A 0 low tia vp vn OPA2810
R32 acin 0 100k
Caflt1 aadc_p 0 330p
Cbadc2 badc_m 0 16p
Rbiso2 bfbm badc_m 4.32
Raint2 aop afbp 22
Xb bip bim bop bom cm v5 0 THS4551
X6B hi highbuf highbuf vp vn OPA2810
C36 lp2 acin 1u
R34 srcfb 0 1k
Cbadc1 badc_p 0 16p
Itest hi low PULSE(0 1u 1u 1n 1n 10u 30u)
C34 lp1 0 1n
Cfba2 afbp aim 100p
RDUT hi low 1T
Rbiso1 bfbp badc_p 4.32
Rbf1 bfbm bip 1k
Raf2 afbp aim 1k
RG source hi 100
Vp vp 0 11.399999999999999
Rdds dds0 dds 200
.control
set klu
optran 1 0 0 0 0 0
set filetype=ascii
set numdgt=17
op
write init-open_lead50_corner-1-order24.raw all
quit
.endc
.end
