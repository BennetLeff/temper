RevC exact full chain; official models; real FDA bias and ADC RC loads
.include ../models/opa2810_a.lib
.include ../models/opa810_a.lib
.include ../models/ths4551.lib
.options reltol=1e-5 abstol=1e-12 vntol=1e-7 method=gear
.include ../final-seed.inc
Rbi1 lowbuf bip 1k
Caflt1 aadc_p 0 330p
Rbint2 bop bfbp 22
Rai2 lowbuf aim 1k
Raint2 aop afbp 22
X7A 0 low tia vp vn OPA2810
X5 acin srcfb excite vp vn OPA810
Chi hi 0 100p
Rai1 highbuf aip 1k
X7B low lowbuf lowbuf vp vn OPA2810
Caadc2 aadc_m 0 16p
Raint1 aom afbm 22
Cfbb2 bfbp bim 100p
Clo low 0 100p
Rbiso2 bfbm badc_m 4.32
Rbf1 bfbm bip 1k
Rbiso1 bfbp badc_p 4.32
X6B hi highbuf highbuf vp vn OPA2810
R31 lp1 lp2 330
Rdds dds0 dds 200
Cfbb1 bfbm bip 100p
Itest hi low PULSE(0 1u 1u 1n 1n 10u 30u)
Caadc1 aadc_p 0 16p
RDUT hi low 1T
Rbi2 tia bim 1k
Raf2 afbp aim 1k
Cbflt2 badc_m 0 330p
R30 dds lp1 330
Cadiff aadc_p aadc_m 3.3n
RF low rf_end 100
Cbadc1 badc_p 0 16p
Cbdiff badc_p badc_m 3.3n
R33 excite srcfb 5k
RG source hi 100
Rbf2 bfbp bim 1k
C35 lp2 0 1n
Cbflt1 badc_p 0 330p
CF low rf_end 95p
R34 srcfb 0 1k
Caflt2 aadc_m 0 330p
Rbint1 bom bfbm 22
Raiso2 afbm aadc_m 4.32
X6A excite source source vp vn OPA2810
C34 lp1 0 1n
V5 v5 0 4.75
R32 acin 0 100k
C36 lp2 acin 1u
Cfba1 afbm aip 100p
Xa aip aim aop aom cm v5 0 THS4551
Raf1 afbm aip 1k
Xb bip bim bop bom cm v5 0 THS4551
Vp vp 0 11.399999999999999
Vcm cm 0 2.048
Vn vn 0 -11.399999999999999
Cfba2 afbp aim 100p
Cbadc2 badc_m 0 16p
Raiso1 afbp aadc_p 4.32
Vdds dds0 0 DC 0.3 AC 1
Lfeedback rf_end tia 50n
.control
set klu
optran 1 0 0 0 0 0
set filetype=ascii
set numdgt=17
op
write init-open_lead50_corner-1-order15.raw all
quit
.endc
.end
