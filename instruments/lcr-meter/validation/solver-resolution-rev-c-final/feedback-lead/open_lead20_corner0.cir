RevC exact full chain; official models; real FDA bias and ADC RC loads
.include ../models/opa2810_a.lib
.include ../models/opa810_a.lib
.include ../models/ths4551.lib
.options reltol=1e-5 abstol=1e-12 vntol=1e-7 method=gear
.include ../final-seed.inc
RF low rf_end 100
X7B low lowbuf lowbuf vp vn OPA2810
Cbadc2 badc_m 0 16p
Cadiff aadc_p aadc_m 3.3n
X6B hi highbuf highbuf vp vn OPA2810
Caflt2 aadc_m 0 330p
R33 excite srcfb 5k
C35 lp2 0 1n
Vdds dds0 0 DC 0.3 AC 1
Vn vn 0 -12
Raint2 aop afbp 22
Raiso1 afbp aadc_p 4.32
Xb bip bim bop bom cm v5 0 THS4551
RDUT hi low 1T
Caflt1 aadc_p 0 330p
Rbi2 tia bim 1k
Itest hi low PULSE(0 1u 1u 1n 1n 10u 30u)
Rdds dds0 dds 200
Cbdiff badc_p badc_m 3.3n
Rbiso2 bfbm badc_m 4.32
Cfbb1 bfbm bip 100p
Rbint2 bop bfbp 22
Rai1 highbuf aip 1k
Rbint1 bom bfbm 22
RG source hi 100
CF low rf_end 100p
Raint1 aom afbm 22
Rbf2 bfbp bim 1k
Caadc2 aadc_m 0 16p
Cfbb2 bfbp bim 100p
C36 lp2 acin 1u
Xa aip aim aop aom cm v5 0 THS4551
Caadc1 aadc_p 0 16p
Cfba1 afbm aip 100p
X7A 0 low tia vp vn OPA2810
Cbflt1 badc_p 0 330p
Lfeedback rf_end tia 20n
R32 acin 0 100k
X6A excite source source vp vn OPA2810
Cbflt2 badc_m 0 330p
X5 acin srcfb excite vp vn OPA810
Cbadc1 badc_p 0 16p
Raiso2 afbm aadc_m 4.32
Rai2 lowbuf aim 1k
V5 v5 0 5
Clo low 0 100p
Vcm cm 0 2.048
Cfba2 afbp aim 100p
Vp vp 0 12
R30 dds lp1 330
Raf2 afbp aim 1k
R31 lp1 lp2 330
R34 srcfb 0 1k
Rbi1 lowbuf bip 1k
Chi hi 0 100p
Rbf1 bfbm bip 1k
C34 lp1 0 1n
Rbiso1 bfbp badc_p 4.32
Raf1 afbm aip 1k
.control
set klu
optran 1 0 0 0 0 0
set filetype=ascii
set wr_singlescale
set wr_vecnames
set numdgt=17
op
write open_lead20_corner0_op.raw all
tran 1n 20u 0 1n
let irg=(v(source)-v(hi))/100
let irf=(v(low)-v(rf_end))/100
let idut=(v(hi)-v(low))/1e12
let ihout=-i(v.x6b.x_h3.vh_h3)
let ilout=-i(v.x7b.x_h3.vh_h3)
let itout=-i(v.x7a.x_h3.vh_h3)
wrdata open_lead20_corner0_tran.dat v(hi) v(low) v(tia) v(highbuf) v(lowbuf) v(rf_end) v(aadc_p) v(aadc_m) v(badc_p) v(badc_m) irg i(Lfeedback) irf idut ihout ilout itout
quit
.endc
.end
