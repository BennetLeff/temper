RevC exact full chain; official models; real FDA bias and ADC RC loads
.include ../models/opa2810_a.lib
.include ../models/opa810_a.lib
.include ../models/ths4551.lib
.options reltol=1e-5 abstol=1e-12 vntol=1e-7 method=gear
.include ../final-seed.inc
Raint1 aom afbm 22
Cbdiff badc_p badc_m 3.3n
Cfba2 afbp aim 100p
Rdds dds0 dds 200
Caflt1 aadc_p 0 330p
Caadc2 aadc_m 0 16p
Rai2 lowbuf aim 1k
Rbint1 bom bfbm 22
Cbadc1 badc_p 0 16p
CF low rf_end 95p
Clo low 0 100p
X7B low lowbuf lowbuf vp vn OPA2810
X7A 0 low tia vp vn OPA2810
Vcm cm 0 2.048
R30 dds lp1 330
Cbadc2 badc_m 0 16p
Vdds dds0 0 DC 0.3 AC 1
Cbflt1 badc_p 0 330p
X6A excite source source vp vn OPA2810
Cfbb1 bfbm bip 100p
Xb bip bim bop bom cm v5 0 THS4551
Itest hi low PULSE(0 1u 1u 1n 1n 10u 30u)
Caadc1 aadc_p 0 16p
RG source hi 100
Raf1 afbm aip 1k
X6B hi highbuf highbuf vp vn OPA2810
Raint2 aop afbp 22
V5 v5 0 4.75
Raf2 afbp aim 1k
Rbf2 bfbp bim 1k
Rbint2 bop bfbp 22
Chi hi 0 100p
Vn vn 0 -11.399999999999999
Rbf1 bfbm bip 1k
X5 acin srcfb excite vp vn OPA810
Caflt2 aadc_m 0 330p
Raiso1 afbp aadc_p 4.32
C36 lp2 acin 1u
Rai1 highbuf aip 1k
R31 lp1 lp2 330
Raiso2 afbm aadc_m 4.32
Rbi2 tia bim 1k
Xa aip aim aop aom cm v5 0 THS4551
Rbiso2 bfbm badc_m 4.32
RDUT hi low 1T
Lfeedback rf_end tia 20n
Rbi1 lowbuf bip 1k
Vp vp 0 11.399999999999999
Rbiso1 bfbp badc_p 4.32
RF low rf_end 100
C34 lp1 0 1n
R32 acin 0 100k
C35 lp2 0 1n
R33 excite srcfb 5k
Cbflt2 badc_m 0 330p
Cfbb2 bfbp bim 100p
R34 srcfb 0 1k
Cfba1 afbm aip 100p
Cadiff aadc_p aadc_m 3.3n
.control
set klu
optran 1 0 0 0 0 0
set filetype=ascii
set numdgt=17
op
write init-open_lead20_corner-1-order23.raw all
quit
.endc
.end
