RevC exact full chain; official models; real FDA bias and ADC RC loads
.include ../models/opa2810_a.lib
.include ../models/opa810_a.lib
.include ../models/ths4551.lib
.options reltol=1e-5 abstol=1e-12 vntol=1e-7 method=gear
.include ../final-seed.inc
Cbflt2 badc_m 0 330p
Vp vp 0 11.399999999999999
Caadc1 aadc_p 0 16p
Cbflt1 badc_p 0 330p
C35 lp2 0 1n
Rbiso1 bfbp badc_p 4.32
Raint1 aom afbm 22
Chi hi 0 100p
R30 dds lp1 330
Rbiso2 bfbm badc_m 4.32
C34 lp1 0 1n
Rbf2 bfbp bim 1k
RG source hi 100
X5 acin srcfb excite vp vn OPA810
Raf2 afbp aim 1k
Rbint1 bom bfbm 22
Rbf1 bfbm bip 1k
Caflt2 aadc_m 0 330p
CF low rf_end 95p
Cbdiff badc_p badc_m 3.3n
V5 v5 0 4.75
Clo low 0 100p
R31 lp1 lp2 330
Cfbb1 bfbm bip 100p
R33 excite srcfb 5k
X7A 0 low tia vp vn OPA2810
Lfeedback rf_end tia 20n
Raiso1 afbp aadc_p 4.32
X6B hi highbuf highbuf vp vn OPA2810
Cfba1 afbm aip 100p
Cfba2 afbp aim 100p
X7B low lowbuf lowbuf vp vn OPA2810
Itest hi low PULSE(0 1u 1u 1n 1n 10u 30u)
Cfbb2 bfbp bim 100p
Xb bip bim bop bom cm v5 0 THS4551
R34 srcfb 0 1k
Raf1 afbm aip 1k
RF low rf_end 100
Rai1 highbuf aip 1k
R32 acin 0 100k
Caadc2 aadc_m 0 16p
Raiso2 afbm aadc_m 4.32
Cadiff aadc_p aadc_m 3.3n
Rbi1 lowbuf bip 1k
Rdds dds0 dds 200
C36 lp2 acin 1u
Rbi2 tia bim 1k
Rai2 lowbuf aim 1k
Cbadc1 badc_p 0 16p
X6A excite source source vp vn OPA2810
Vn vn 0 -11.399999999999999
Cbadc2 badc_m 0 16p
Vdds dds0 0 DC 0.3 AC 1
Caflt1 aadc_p 0 330p
RDUT hi low 1T
Rbint2 bop bfbp 22
Xa aip aim aop aom cm v5 0 THS4551
Raint2 aop afbp 22
Vcm cm 0 2.048
.control
set klu
optran 1 0 0 0 0 0
set filetype=ascii
set numdgt=17
op
write init-open_lead20_corner-1-order20.raw all
quit
.endc
.end
