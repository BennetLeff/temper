RevC exact full chain; official models; real FDA bias and ADC RC loads
.include ../models/opa2810_a.lib
.include ../models/opa810_a.lib
.include ../models/ths4551.lib
.options reltol=1e-5 abstol=1e-12 vntol=1e-7 method=gear
.include ../final-seed.inc
Raint1 aom afbm 22
Rdds dds0 dds 200
Raf2 afbp aim 1k
Vn vn 0 -11.399999999999999
Caadc2 aadc_m 0 16p
Raf1 afbm aip 1k
RDUT hi low 1T
X7B low lowbuf lowbuf vp vn OPA2810
RF low rf_end 100
Rbint1 bom bfbm 22
C36 lp2 acin 1u
Rbf2 bfbp bim 1k
Rbi2 tia bim 1k
Vcm cm 0 2.048
C34 lp1 0 1n
X6B hi highbuf highbuf vp vn OPA2810
Lfeedback rf_end tia 50n
Cbflt1 badc_p 0 330p
CF low rf_end 95p
Caadc1 aadc_p 0 16p
Raint2 aop afbp 22
R34 srcfb 0 1k
Rbint2 bop bfbp 22
V5 v5 0 4.75
Rai2 lowbuf aim 1k
Cbadc1 badc_p 0 16p
R30 dds lp1 330
Vdds dds0 0 DC 0.3 AC 1
Cfbb1 bfbm bip 100p
RG source hi 100
Cbadc2 badc_m 0 16p
Rbiso2 bfbm badc_m 4.32
Cbdiff badc_p badc_m 3.3n
X6A excite source source vp vn OPA2810
Caflt1 aadc_p 0 330p
Cfba2 afbp aim 100p
Xa aip aim aop aom cm v5 0 THS4551
R33 excite srcfb 5k
Itest hi low PULSE(0 1u 1u 1n 1n 10u 30u)
Clo low 0 100p
Raiso1 afbp aadc_p 4.32
X7A 0 low tia vp vn OPA2810
Xb bip bim bop bom cm v5 0 THS4551
Rbiso1 bfbp badc_p 4.32
Cadiff aadc_p aadc_m 3.3n
R32 acin 0 100k
Cfba1 afbm aip 100p
Caflt2 aadc_m 0 330p
Rai1 highbuf aip 1k
Rbf1 bfbm bip 1k
Chi hi 0 100p
C35 lp2 0 1n
Vp vp 0 11.399999999999999
Cfbb2 bfbp bim 100p
R31 lp1 lp2 330
Rbi1 lowbuf bip 1k
Raiso2 afbm aadc_m 4.32
Cbflt2 badc_m 0 330p
X5 acin srcfb excite vp vn OPA810
.control
set klu
optran 1 0 0 0 0 0
set filetype=ascii
set numdgt=17
op
write init-open_lead50_corner-1-order19.raw all
quit
.endc
.end
