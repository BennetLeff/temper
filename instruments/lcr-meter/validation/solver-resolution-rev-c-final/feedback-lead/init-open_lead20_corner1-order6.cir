RevC exact full chain; official models; real FDA bias and ADC RC loads
.include ../models/opa2810_a.lib
.include ../models/opa810_a.lib
.include ../models/ths4551.lib
.options reltol=1e-5 abstol=1e-12 vntol=1e-7 method=gear
.include ../final-seed.inc
Raf1 afbm aip 1k
Cbflt2 badc_m 0 330p
X5 acin srcfb excite vp vn OPA810
Cfbb1 bfbm bip 100p
Rbint2 bop bfbp 22
R34 srcfb 0 1k
Cbadc1 badc_p 0 16p
Rbf2 bfbp bim 1k
X7B low lowbuf lowbuf vp vn OPA2810
C36 lp2 acin 1u
RDUT hi low 1T
Caadc1 aadc_p 0 16p
Rdds dds0 dds 200
RF low rf_end 100
Vp vp 0 12.600000000000001
Cfbb2 bfbp bim 100p
CF low rf_end 105p
X7A 0 low tia vp vn OPA2810
Chi hi 0 100p
Cadiff aadc_p aadc_m 3.3n
Caflt2 aadc_m 0 330p
Rbiso2 bfbm badc_m 4.32
Xb bip bim bop bom cm v5 0 THS4551
V5 v5 0 5.25
RG source hi 100
Raf2 afbp aim 1k
Cbdiff badc_p badc_m 3.3n
Clo low 0 100p
R33 excite srcfb 5k
R32 acin 0 100k
Rai1 highbuf aip 1k
Cfba1 afbm aip 100p
Raint1 aom afbm 22
Xa aip aim aop aom cm v5 0 THS4551
Cfba2 afbp aim 100p
Raiso2 afbm aadc_m 4.32
Raiso1 afbp aadc_p 4.32
R31 lp1 lp2 330
Rbiso1 bfbp badc_p 4.32
Cbadc2 badc_m 0 16p
Rbi1 lowbuf bip 1k
Rai2 lowbuf aim 1k
Raint2 aop afbp 22
Rbf1 bfbm bip 1k
C35 lp2 0 1n
R30 dds lp1 330
Vn vn 0 -12.600000000000001
Vdds dds0 0 DC 0.3 AC 1
Caflt1 aadc_p 0 330p
X6B hi highbuf highbuf vp vn OPA2810
Rbint1 bom bfbm 22
Vcm cm 0 2.048
Rbi2 tia bim 1k
Lfeedback rf_end tia 20n
C34 lp1 0 1n
Caadc2 aadc_m 0 16p
X6A excite source source vp vn OPA2810
Cbflt1 badc_p 0 330p
Itest hi low PULSE(0 1u 1u 1n 1n 10u 30u)
.control
set klu
optran 1 0 0 0 0 0
set filetype=ascii
set numdgt=17
op
write init-open_lead20_corner1-order6.raw all
quit
.endc
.end
