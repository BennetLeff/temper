RevC exact full chain; official models; real FDA bias and ADC RC loads
.include ../models/opa2810_a.lib
.include ../models/opa810_a.lib
.include ../models/ths4551.lib
.options reltol=1e-5 abstol=1e-12 vntol=1e-7 method=gear
.include ../final-seed.inc
Rbf2 bfbp bim 1k
Itest hi low PULSE(0 1u 1u 1n 1n 10u 30u)
Caflt1 aadc_p 0 330p
Cbadc1 badc_p 0 16p
X7A 0 low tia vp vn OPA2810
Cfbb2 bfbp bim 100p
Vdds dds0 0 DC 0.3 AC 1
Vp vp 0 12
Rbi2 tia bim 1k
Raiso2 afbm aadc_m 4.32
Raf1 afbm aip 1k
Caadc1 aadc_p 0 16p
Cbadc2 badc_m 0 16p
Xb bip bim bop bom cm v5 0 THS4551
Cbflt1 badc_p 0 330p
Xa aip aim aop aom cm v5 0 THS4551
Cfba2 afbp aim 100p
Rdds dds0 dds 200
X5 acin srcfb excite vp vn OPA810
Raint1 aom afbm 22
Rbf1 bfbm bip 1k
Rbi1 lowbuf bip 1k
RDUT hi low 1T
Rbiso1 bfbp badc_p 4.32
Cbdiff badc_p badc_m 3.3n
Raiso1 afbp aadc_p 4.32
R31 lp1 lp2 330
Chi hi 0 100p
Cfbb1 bfbm bip 100p
Rai2 lowbuf aim 1k
R34 srcfb 0 1k
X7B low lowbuf lowbuf vp vn OPA2810
Rbiso2 bfbm badc_m 4.32
Raint2 aop afbp 22
C34 lp1 0 1n
Cfba1 afbm aip 100p
Caadc2 aadc_m 0 16p
X6A excite source source vp vn OPA2810
C36 lp2 acin 1u
Rbint2 bop bfbp 22
Cbflt2 badc_m 0 330p
RG source hi 100
R32 acin 0 100k
Caflt2 aadc_m 0 330p
RF low rf_end 100
Rai1 highbuf aip 1k
C35 lp2 0 1n
Lfeedback rf_end tia 20n
X6B hi highbuf highbuf vp vn OPA2810
V5 v5 0 5
Cadiff aadc_p aadc_m 3.3n
Vcm cm 0 2.048
Clo low 0 100p
Vn vn 0 -12
CF low rf_end 100p
Raf2 afbp aim 1k
Rbint1 bom bfbm 22
R30 dds lp1 330
R33 excite srcfb 5k
.control
set klu
optran 1 0 0 0 0 0
set filetype=ascii
set numdgt=17
op
write init-open_lead20_corner0-order2.raw all
quit
.endc
.end
