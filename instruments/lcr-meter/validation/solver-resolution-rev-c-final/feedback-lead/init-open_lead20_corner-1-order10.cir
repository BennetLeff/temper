RevC exact full chain; official models; real FDA bias and ADC RC loads
.include ../models/opa2810_a.lib
.include ../models/opa810_a.lib
.include ../models/ths4551.lib
.options reltol=1e-5 abstol=1e-12 vntol=1e-7 method=gear
.include ../final-seed.inc
Raf2 afbp aim 1k
Cbadc1 badc_p 0 16p
X6A excite source source vp vn OPA2810
Caadc2 aadc_m 0 16p
Clo low 0 100p
Cbadc2 badc_m 0 16p
Cadiff aadc_p aadc_m 3.3n
Rbi2 tia bim 1k
X5 acin srcfb excite vp vn OPA810
Raiso2 afbm aadc_m 4.32
C36 lp2 acin 1u
CF low rf_end 95p
RF low rf_end 100
Raint1 aom afbm 22
V5 v5 0 4.75
X7B low lowbuf lowbuf vp vn OPA2810
Xb bip bim bop bom cm v5 0 THS4551
Cbdiff badc_p badc_m 3.3n
Itest hi low PULSE(0 1u 1u 1n 1n 10u 30u)
R31 lp1 lp2 330
Rbiso1 bfbp badc_p 4.32
Cfbb2 bfbp bim 100p
R30 dds lp1 330
R34 srcfb 0 1k
Vdds dds0 0 DC 0.3 AC 1
Rbint2 bop bfbp 22
Cfba2 afbp aim 100p
Xa aip aim aop aom cm v5 0 THS4551
R33 excite srcfb 5k
Raint2 aop afbp 22
Rbf2 bfbp bim 1k
R32 acin 0 100k
Vp vp 0 11.399999999999999
Rai2 lowbuf aim 1k
Cbflt2 badc_m 0 330p
X6B hi highbuf highbuf vp vn OPA2810
Cfba1 afbm aip 100p
X7A 0 low tia vp vn OPA2810
Vcm cm 0 2.048
RDUT hi low 1T
RG source hi 100
Rbiso2 bfbm badc_m 4.32
Vn vn 0 -11.399999999999999
Chi hi 0 100p
Rbint1 bom bfbm 22
C35 lp2 0 1n
Cfbb1 bfbm bip 100p
C34 lp1 0 1n
Raf1 afbm aip 1k
Caflt1 aadc_p 0 330p
Rbi1 lowbuf bip 1k
Caflt2 aadc_m 0 330p
Cbflt1 badc_p 0 330p
Rbf1 bfbm bip 1k
Rdds dds0 dds 200
Rai1 highbuf aip 1k
Lfeedback rf_end tia 20n
Raiso1 afbp aadc_p 4.32
Caadc1 aadc_p 0 16p
.control
set klu
optran 1 0 0 0 0 0
set filetype=ascii
set numdgt=17
op
write init-open_lead20_corner-1-order10.raw all
quit
.endc
.end
