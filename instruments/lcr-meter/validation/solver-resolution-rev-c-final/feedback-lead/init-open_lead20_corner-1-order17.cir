RevC exact full chain; official models; real FDA bias and ADC RC loads
.include ../models/opa2810_a.lib
.include ../models/opa810_a.lib
.include ../models/ths4551.lib
.options reltol=1e-5 abstol=1e-12 vntol=1e-7 method=gear
.include ../final-seed.inc
Cbflt1 badc_p 0 330p
X6A excite source source vp vn OPA2810
Caadc2 aadc_m 0 16p
Cfbb2 bfbp bim 100p
Raiso2 afbm aadc_m 4.32
Vn vn 0 -11.399999999999999
Cfba1 afbm aip 100p
Raf1 afbm aip 1k
Cadiff aadc_p aadc_m 3.3n
Caflt1 aadc_p 0 330p
Rbf2 bfbp bim 1k
Rbf1 bfbm bip 1k
Raiso1 afbp aadc_p 4.32
Rbi2 tia bim 1k
X7A 0 low tia vp vn OPA2810
Cbadc2 badc_m 0 16p
Vdds dds0 0 DC 0.3 AC 1
Raf2 afbp aim 1k
Chi hi 0 100p
Rbint1 bom bfbm 22
Xb bip bim bop bom cm v5 0 THS4551
Caadc1 aadc_p 0 16p
Vcm cm 0 2.048
RF low rf_end 100
Clo low 0 100p
Raint1 aom afbm 22
CF low rf_end 95p
R31 lp1 lp2 330
Rbiso2 bfbm badc_m 4.32
X6B hi highbuf highbuf vp vn OPA2810
Raint2 aop afbp 22
R30 dds lp1 330
Cfbb1 bfbm bip 100p
Itest hi low PULSE(0 1u 1u 1n 1n 10u 30u)
Cbdiff badc_p badc_m 3.3n
C36 lp2 acin 1u
C34 lp1 0 1n
Rai2 lowbuf aim 1k
Rbi1 lowbuf bip 1k
Cbflt2 badc_m 0 330p
Cfba2 afbp aim 100p
X5 acin srcfb excite vp vn OPA810
Lfeedback rf_end tia 20n
V5 v5 0 4.75
Rdds dds0 dds 200
Vp vp 0 11.399999999999999
Cbadc1 badc_p 0 16p
X7B low lowbuf lowbuf vp vn OPA2810
Rbiso1 bfbp badc_p 4.32
RG source hi 100
Caflt2 aadc_m 0 330p
RDUT hi low 1T
Rbint2 bop bfbp 22
Xa aip aim aop aom cm v5 0 THS4551
R32 acin 0 100k
R34 srcfb 0 1k
Rai1 highbuf aip 1k
C35 lp2 0 1n
R33 excite srcfb 5k
.control
set klu
optran 1 0 0 0 0 0
set filetype=ascii
set numdgt=17
op
write init-open_lead20_corner-1-order17.raw all
quit
.endc
.end
