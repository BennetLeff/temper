RevC exact full chain; official models; real FDA bias and ADC RC loads
.include ../models/opa2810_a.lib
.include ../models/opa810_a.lib
.include ../models/ths4551.lib
.options reltol=1e-5 abstol=1e-12 vntol=1e-7 method=gear
.include ../final-seed.inc
Lfeedback rf_end tia 20n
RDUT hi low 1T
Rai1 highbuf aip 1k
Clo low 0 100p
Cadiff aadc_p aadc_m 3.3n
Raiso1 afbp aadc_p 4.32
Rdds dds0 dds 200
Vcm cm 0 2.048
Xa aip aim aop aom cm v5 0 THS4551
C36 lp2 acin 1u
Rbf2 bfbp bim 1k
C34 lp1 0 1n
Cbdiff badc_p badc_m 3.3n
Rbiso2 bfbm badc_m 4.32
Vdds dds0 0 DC 0.3 AC 1
Rbint2 bop bfbp 22
Raint2 aop afbp 22
R30 dds lp1 330
Rbi2 tia bim 1k
Raiso2 afbm aadc_m 4.32
Raf1 afbm aip 1k
Chi hi 0 100p
Cfbb2 bfbp bim 100p
R31 lp1 lp2 330
Cfba2 afbp aim 100p
Rai2 lowbuf aim 1k
CF low rf_end 100p
Xb bip bim bop bom cm v5 0 THS4551
Cbflt1 badc_p 0 330p
Rbf1 bfbm bip 1k
Rbint1 bom bfbm 22
X6B hi highbuf highbuf vp vn OPA2810
R34 srcfb 0 1k
Raf2 afbp aim 1k
Cbadc1 badc_p 0 16p
V5 v5 0 5
Itest hi low PULSE(0 1u 1u 1n 1n 10u 30u)
RG source hi 100
Caadc2 aadc_m 0 16p
X5 acin srcfb excite vp vn OPA810
Raint1 aom afbm 22
X7B low lowbuf lowbuf vp vn OPA2810
Caadc1 aadc_p 0 16p
X6A excite source source vp vn OPA2810
Caflt2 aadc_m 0 330p
Cfba1 afbm aip 100p
C35 lp2 0 1n
X7A 0 low tia vp vn OPA2810
Vp vp 0 12
Rbiso1 bfbp badc_p 4.32
Rbi1 lowbuf bip 1k
Cbadc2 badc_m 0 16p
Cbflt2 badc_m 0 330p
Caflt1 aadc_p 0 330p
R32 acin 0 100k
Cfbb1 bfbm bip 100p
Vn vn 0 -12
R33 excite srcfb 5k
RF low rf_end 100
.control
set klu
optran 1 0 0 0 0 0
set filetype=ascii
set numdgt=17
op
write init-open_lead20_corner0-order1.raw all
quit
.endc
.end
