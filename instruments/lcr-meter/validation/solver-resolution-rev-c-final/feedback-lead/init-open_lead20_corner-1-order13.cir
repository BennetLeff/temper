RevC exact full chain; official models; real FDA bias and ADC RC loads
.include ../models/opa2810_a.lib
.include ../models/opa810_a.lib
.include ../models/ths4551.lib
.options reltol=1e-5 abstol=1e-12 vntol=1e-7 method=gear
.include ../final-seed.inc
Raf2 afbp aim 1k
Vp vp 0 11.399999999999999
Lfeedback rf_end tia 20n
Clo low 0 100p
Cbadc1 badc_p 0 16p
Rbint1 bom bfbm 22
Cadiff aadc_p aadc_m 3.3n
Rdds dds0 dds 200
Caflt1 aadc_p 0 330p
Cbflt2 badc_m 0 330p
Rbi2 tia bim 1k
X7B low lowbuf lowbuf vp vn OPA2810
Vdds dds0 0 DC 0.3 AC 1
Cfba1 afbm aip 100p
Chi hi 0 100p
Rbiso2 bfbm badc_m 4.32
Cbadc2 badc_m 0 16p
RDUT hi low 1T
Rbint2 bop bfbp 22
Vcm cm 0 2.048
X6A excite source source vp vn OPA2810
X6B hi highbuf highbuf vp vn OPA2810
Raiso1 afbp aadc_p 4.32
Itest hi low PULSE(0 1u 1u 1n 1n 10u 30u)
Vn vn 0 -11.399999999999999
RG source hi 100
Rbf1 bfbm bip 1k
C34 lp1 0 1n
X7A 0 low tia vp vn OPA2810
Cfbb1 bfbm bip 100p
Raint2 aop afbp 22
Raint1 aom afbm 22
Rai2 lowbuf aim 1k
R30 dds lp1 330
Raf1 afbm aip 1k
R32 acin 0 100k
Rbi1 lowbuf bip 1k
R33 excite srcfb 5k
Cbdiff badc_p badc_m 3.3n
C35 lp2 0 1n
CF low rf_end 95p
Caflt2 aadc_m 0 330p
R34 srcfb 0 1k
Xa aip aim aop aom cm v5 0 THS4551
Rbf2 bfbp bim 1k
Rai1 highbuf aip 1k
Rbiso1 bfbp badc_p 4.32
Caadc1 aadc_p 0 16p
X5 acin srcfb excite vp vn OPA810
Caadc2 aadc_m 0 16p
Raiso2 afbm aadc_m 4.32
C36 lp2 acin 1u
R31 lp1 lp2 330
V5 v5 0 4.75
Xb bip bim bop bom cm v5 0 THS4551
Cfbb2 bfbp bim 100p
Cfba2 afbp aim 100p
Cbflt1 badc_p 0 330p
RF low rf_end 100
.control
set klu
optran 1 0 0 0 0 0
set filetype=ascii
set numdgt=17
op
write init-open_lead20_corner-1-order13.raw all
quit
.endc
.end
