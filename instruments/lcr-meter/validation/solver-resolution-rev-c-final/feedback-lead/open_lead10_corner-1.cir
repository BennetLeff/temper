RevC exact full chain; official models; real FDA bias and ADC RC loads
.include ../models/opa2810_a.lib
.include ../models/opa810_a.lib
.include ../models/ths4551.lib
.options reltol=1e-5 abstol=1e-12 vntol=1e-7 method=gear
.include ../final-seed.inc
Rbf2 bfbp bim 1k
C36 lp2 acin 1u
Chi hi 0 100p
Cfbb2 bfbp bim 100p
CF low rf_end 95p
Vn vn 0 -11.399999999999999
X6A excite source source vp vn OPA2810
Raiso1 afbp aadc_p 4.32
RG source hi 100
Rbf1 bfbm bip 1k
Cbdiff badc_p badc_m 3.3n
Raf2 afbp aim 1k
V5 v5 0 4.75
C34 lp1 0 1n
Rbiso1 bfbp badc_p 4.32
R32 acin 0 100k
Rdds dds0 dds 200
Caadc1 aadc_p 0 16p
Caflt2 aadc_m 0 330p
Rbint2 bop bfbp 22
RF low rf_end 100
Cadiff aadc_p aadc_m 3.3n
Rbi1 lowbuf bip 1k
Vcm cm 0 2.048
Cfba1 afbm aip 100p
R31 lp1 lp2 330
Itest hi low PULSE(0 1u 1u 1n 1n 10u 30u)
Vp vp 0 11.399999999999999
X7A 0 low tia vp vn OPA2810
Rai1 highbuf aip 1k
Raint2 aop afbp 22
Cbflt2 badc_m 0 330p
Raf1 afbm aip 1k
Rbiso2 bfbm badc_m 4.32
R30 dds lp1 330
X6B hi highbuf highbuf vp vn OPA2810
C35 lp2 0 1n
Xa aip aim aop aom cm v5 0 THS4551
X5 acin srcfb excite vp vn OPA810
Xb bip bim bop bom cm v5 0 THS4551
RDUT hi low 1T
Caflt1 aadc_p 0 330p
R34 srcfb 0 1k
Rai2 lowbuf aim 1k
Cbadc1 badc_p 0 16p
Caadc2 aadc_m 0 16p
Raiso2 afbm aadc_m 4.32
Cbflt1 badc_p 0 330p
Cfba2 afbp aim 100p
Vdds dds0 0 DC 0.3 AC 1
Cbadc2 badc_m 0 16p
Cfbb1 bfbm bip 100p
Rbi2 tia bim 1k
Clo low 0 100p
Raint1 aom afbm 22
Lfeedback rf_end tia 10n
R33 excite srcfb 5k
Rbint1 bom bfbm 22
X7B low lowbuf lowbuf vp vn OPA2810
.control
set klu
optran 1 0 0 0 0 0
set filetype=ascii
set wr_singlescale
set wr_vecnames
set numdgt=17
op
write open_lead10_corner-1_op.raw all
tran 1n 20u 0 1n
let irg=(v(source)-v(hi))/100
let irf=(v(low)-v(rf_end))/100
let idut=(v(hi)-v(low))/1e12
let ihout=-i(v.x6b.x_h3.vh_h3)
let ilout=-i(v.x7b.x_h3.vh_h3)
let itout=-i(v.x7a.x_h3.vh_h3)
wrdata open_lead10_corner-1_tran.dat v(hi) v(low) v(tia) v(highbuf) v(lowbuf) v(rf_end) v(aadc_p) v(aadc_m) v(badc_p) v(badc_m) irg i(Lfeedback) irf idut ihout ilout itout
quit
.endc
.end
