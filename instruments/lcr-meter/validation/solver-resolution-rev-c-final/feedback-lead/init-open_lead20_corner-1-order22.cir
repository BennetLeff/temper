RevC exact full chain; official models; real FDA bias and ADC RC loads
.include ../models/opa2810_a.lib
.include ../models/opa810_a.lib
.include ../models/ths4551.lib
.options reltol=1e-5 abstol=1e-12 vntol=1e-7 method=gear
.include ../final-seed.inc
Cbflt2 badc_m 0 330p
Rai2 lowbuf aim 1k
Caflt2 aadc_m 0 330p
Rbiso2 bfbm badc_m 4.32
Itest hi low PULSE(0 1u 1u 1n 1n 10u 30u)
Caadc2 aadc_m 0 16p
X5 acin srcfb excite vp vn OPA810
Rbi2 tia bim 1k
Vp vp 0 11.399999999999999
Cfba1 afbm aip 100p
R30 dds lp1 330
R31 lp1 lp2 330
Rbiso1 bfbp badc_p 4.32
Raiso2 afbm aadc_m 4.32
Rbint1 bom bfbm 22
Xa aip aim aop aom cm v5 0 THS4551
Rdds dds0 dds 200
RDUT hi low 1T
Raint1 aom afbm 22
Xb bip bim bop bom cm v5 0 THS4551
Caflt1 aadc_p 0 330p
Cfbb2 bfbp bim 100p
Clo low 0 100p
X6B hi highbuf highbuf vp vn OPA2810
Rbf1 bfbm bip 1k
R34 srcfb 0 1k
Cbflt1 badc_p 0 330p
Rbi1 lowbuf bip 1k
RF low rf_end 100
Cadiff aadc_p aadc_m 3.3n
C34 lp1 0 1n
Vn vn 0 -11.399999999999999
Rai1 highbuf aip 1k
C36 lp2 acin 1u
Cbadc1 badc_p 0 16p
Lfeedback rf_end tia 20n
Cfbb1 bfbm bip 100p
Raf2 afbp aim 1k
R33 excite srcfb 5k
Raint2 aop afbp 22
Cbdiff badc_p badc_m 3.3n
X6A excite source source vp vn OPA2810
Cfba2 afbp aim 100p
X7B low lowbuf lowbuf vp vn OPA2810
C35 lp2 0 1n
CF low rf_end 95p
Rbf2 bfbp bim 1k
RG source hi 100
Caadc1 aadc_p 0 16p
Vcm cm 0 2.048
Chi hi 0 100p
Rbint2 bop bfbp 22
X7A 0 low tia vp vn OPA2810
Cbadc2 badc_m 0 16p
V5 v5 0 4.75
Raiso1 afbp aadc_p 4.32
Vdds dds0 0 DC 0.3 AC 1
R32 acin 0 100k
Raf1 afbm aip 1k
.control
set klu
optran 1 0 0 0 0 0
set filetype=ascii
set numdgt=17
op
write init-open_lead20_corner-1-order22.raw all
quit
.endc
.end
