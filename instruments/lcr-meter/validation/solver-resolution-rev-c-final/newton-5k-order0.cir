RevC exact full chain; official models; real FDA bias and ADC RC loads
.include models/opa2810_a.lib
.include models/opa810_a.lib
.include models/ths4551.lib
.options reltol=1e-5 abstol=1e-12 vntol=1e-7 method=gear
.include final-seed.inc
Rbiso1 bfbp badc_p 4.32
Cfbb1 bfbm bip 100p
Raint1 aom afbm 22
RG source hi 5000
Rbint1 bom bfbm 22
Vp vp 0 12
X7B low lowbuf lowbuf vp vn OPA2810
R32 acin 0 100k
Rbf1 bfbm bip 1k
C35 lp2 0 1n
Rbiso2 bfbm badc_m 4.32
Rai2 lowbuf aim 1k
Rai1 highbuf aip 1k
Cbadc2 badc_m 0 16p
Cadiff aadc_p aadc_m 3.3n
Rbf2 bfbp bim 1k
X7A 0 low tia vp vn OPA2810
Raf2 afbp aim 1k
Caadc2 aadc_m 0 16p
Vcm cm 0 2.048
R31 lp1 lp2 330
Raiso1 afbp aadc_p 4.32
Xb bip bim bop bom cm v5 0 THS4551
Xa aip aim aop aom cm v5 0 THS4551
RF low tia 5000
Caflt1 aadc_p 0 330p
Cfbb2 bfbp bim 100p
X6B hi highbuf highbuf vp vn OPA2810
CF low tia 10p
Vdds dds0 0 DC 0.3 AC 1 SIN(0.3 0.3 50k)
Vn vn 0 -12
Cbdiff badc_p badc_m 3.3n
Raiso2 afbm aadc_m 4.32
R34 srcfb 0 1k
Rbint2 bop bfbp 22
C34 lp1 0 1n
X6A excite source source vp vn OPA2810
X5 acin srcfb excite vp vn OPA810
C36 lp2 acin 1u
Cbflt1 badc_p 0 330p
R33 excite srcfb 5k
RDUT hi low 5000
Raint2 aop afbp 22
Cbflt2 badc_m 0 330p
R30 dds lp1 330
Cbadc1 badc_p 0 16p
Caflt2 aadc_m 0 330p
Rdds dds0 dds 200
Caadc1 aadc_p 0 16p
Raf1 afbm aip 1k
Rbi2 tia bim 1k
Cfba1 afbm aip 100p
Rbi1 lowbuf bip 1k
Cfba2 afbp aim 100p
V5 v5 0 5
.control
set klu
optran 1 0 0 0 0 0
set filetype=ascii
set numdgt=17
op
write newton-5k-order0.raw all
quit
.endc
.end
