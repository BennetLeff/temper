RevC exact full chain; official models; real FDA bias and ADC RC loads
.include models/opa2810_a.lib
.include models/opa810_a.lib
.include models/ths4551.lib
.options reltol=1e-5 abstol=1e-12 vntol=1e-7 method=gear
.include final-seed.inc
V5 v5 0 5
Cfba2 afbp aim 100p
Rbi1 lowbuf bip 1k
Cfba1 afbm aip 100p
Rbi2 tia bim 1k
Raf1 afbm aip 1k
Caadc1 aadc_p 0 16p
Rdds dds0 dds 200
Caflt2 aadc_m 0 330p
Cbadc1 badc_p 0 16p
R30 dds lp1 330
Cbflt2 badc_m 0 330p
Raint2 aop afbp 22
RDUT hi low 5000
R33 excite srcfb 5k
Cbflt1 badc_p 0 330p
C36 lp2 acin 1u
X5 acin srcfb excite vp vn OPA810
X6A excite source source vp vn OPA2810
C34 lp1 0 1n
Rbint2 bop bfbp 22
R34 srcfb 0 1k
Raiso2 afbm aadc_m 4.32
Cbdiff badc_p badc_m 3.3n
Vn vn 0 -12
Vdds dds0 0 DC 0.3 AC 1 SIN(0.3 0.3 50k)
CF low tia 10p
X6B hi highbuf highbuf vp vn OPA2810
Cfbb2 bfbp bim 100p
Caflt1 aadc_p 0 330p
RF low tia 5000
Xa aip aim aop aom cm v5 0 THS4551
Xb bip bim bop bom cm v5 0 THS4551
Raiso1 afbp aadc_p 4.32
R31 lp1 lp2 330
Vcm cm 0 2.048
Caadc2 aadc_m 0 16p
Raf2 afbp aim 1k
X7A 0 low tia vp vn OPA2810
Rbf2 bfbp bim 1k
Cadiff aadc_p aadc_m 3.3n
Cbadc2 badc_m 0 16p
Rai1 highbuf aip 1k
Rai2 lowbuf aim 1k
Rbiso2 bfbm badc_m 4.32
C35 lp2 0 1n
Rbf1 bfbm bip 1k
R32 acin 0 100k
X7B low lowbuf lowbuf vp vn OPA2810
Vp vp 0 12
Rbint1 bom bfbm 22
RG source hi 5000
Raint1 aom afbm 22
Cfbb1 bfbm bip 100p
Rbiso1 bfbp badc_p 4.32
.control
set klu
optran 1 0 0 0 0 0
set filetype=ascii
set numdgt=17
op
write newton-5k-order1.raw all
quit
.endc
.end
