RevC exact full chain; official models; real FDA bias and ADC RC loads
.include models/opa2810_a.lib
.include models/opa810_a.lib
.include models/ths4551.lib
.options reltol=1e-5 abstol=1e-12 vntol=1e-7 method=gear
.include final-seed.inc
Cfba2 afbp aim 100p
Raint2 aop afbp 22
Rai1 highbuf aip 1k
X7A 0 low tia vp vn OPA2810
Cbdiff badc_p badc_m 3.3n
X6B hi highbuf highbuf vp vn OPA2810
Cbadc1 badc_p 0 16p
Rbint2 bop bfbp 22
Xa aip aim aop aom cm v5 0 THS4551
Rbf1 bfbm bip 1k
Cfba1 afbm aip 100p
Caadc2 aadc_m 0 16p
Raiso1 afbp aadc_p 4.32
Caadc1 aadc_p 0 16p
Cbadc2 badc_m 0 16p
Raf2 afbp aim 1k
CF low tia 100p
Rbiso1 bfbp badc_p 4.32
Vp vp 0 12
Vdds dds0 0 DC 0.3 AC 1
C36 lp2 acin 1u
Caflt1 aadc_p 0 330p
CDUT hi low 100n
Raiso2 afbm aadc_m 4.32
R32 acin 0 100k
Rdds dds0 dds 200
R30 dds lp1 330
Vcm cm 0 DC 2.048 PULSE(2.048 2.058 1u 10n 10n 5u 12u)
Xb bip bim bop bom cm v5 0 THS4551
Caflt2 aadc_m 0 330p
Raint1 aom afbm 22
Cbflt1 badc_p 0 330p
Cadiff aadc_p aadc_m 3.3n
Rbi1 lowbuf bip 1k
X5 acin srcfb excite vp vn OPA810
Rbf2 bfbp bim 1k
R34 srcfb 0 1k
R33 excite srcfb 5k
RF low tia 100
C34 lp1 0 1n
Vn vn 0 -12
R31 lp1 lp2 330
Cfbb1 bfbm bip 100p
C35 lp2 0 1n
V5 v5 0 5
RG source hi 100
Cfbb2 bfbp bim 100p
Rbint1 bom bfbm 22
X7B low lowbuf lowbuf vp vn OPA2810
Rbi2 tia bim 1k
Cbflt2 badc_m 0 330p
Rai2 lowbuf aim 1k
Rbiso2 bfbm badc_m 4.32
X6A excite source source vp vn OPA2810
Raf1 afbm aip 1k
.control
set klu
optran 1 0 0 0 0 0
set wr_singlescale
set wr_vecnames
set filetype=ascii
op
write cm100r_op.raw all
tran 1n 10u 0 1n
let acm=(v(aadc_p)+v(aadc_m))/2
let bcm=(v(badc_p)+v(badc_m))/2
let adiff=v(aadc_p)-v(aadc_m)
let bdiff=v(badc_p)-v(badc_m)
wrdata cm100r_tran.dat v(cm) acm bcm adiff bdiff v(highbuf) v(lowbuf) v(tia)
quit
.endc
.end
