RevC exact full chain; official models; real FDA bias and ADC RC loads
.include models/opa2810_a.lib
.include models/opa810_a.lib
.include models/ths4551.lib
.options reltol=1e-5 abstol=1e-12 vntol=1e-7 method=gear
Vp vp 0 12
Vn vn 0 -12
V5 v5 0 5
Vcm cm 0 2.048
Vdds dds0 0 DC 0.3 AC 1
Rdds dds0 dds 200
R30 dds lp1 330
C34 lp1 0 1n
R31 lp1 lp2 330
C35 lp2 0 1n
C36 lp2 acin 1u
R32 acin 0 100k
X5 acin srcfb excite vp vn OPA810
R33 excite srcfb 5k
R34 srcfb 0 1k
X6A excite source source vp vn OPA2810
RG source hi 100
CDUT hi low 100n
RF low tia 100
CF low tia 100p
X6B hi highbuf highbuf vp vn OPA2810
X7B low lowbuf lowbuf vp vn OPA2810
X7A 0 low tia vp vn OPA2810
Vaip aip 0 1.013389949794677
Vaim aim 0 1.013410943381595
Vbip bip 0 1.013224126874695
Vbim bim 0 1.01324512123348
Rai1 highbuf aip 1k
Rai2 lowbuf aim 1k
Rbi1 lowbuf bip 1k
Rbi2 tia bim 1k
.control
set klu
set filetype=ascii
op
write afe-loaded.raw all
quit
.endc
.end
