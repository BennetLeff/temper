RevC exact full chain; official models; real FDA bias and ADC RC loads
.include models/opa2810_a.lib
.include models/opa810_a.lib
.include models/ths4551.lib
.options reltol=1e-5 abstol=1e-12 vntol=1e-7 method=gear
.include final-seed.inc
Cbadc1 badc_p 0 16p
Rbf2 bfbp bim 1k
C35 lp2 0 1n
RDUT hi low 5000
R32 acin 0 100k
Rbf1 bfbm bip 1k
Raint2 aop afbp 22
C34 lp1 0 1n
R30 dds lp1 330
Cbflt2 badc_m 0 330p
X5 acin srcfb excite vp vn OPA810
C36 lp2 acin 1u
Cfba2 afbp aim 100p
Vcm cm 0 2.048
X6B hi highbuf highbuf vp vn OPA2810
RF low tia 5000
X7A 0 low tia vp vn OPA2810
X6A excite source source vp vn OPA2810
Rbint2 bop bfbp 22
Vn vn 0 -12.6
Xa aip aim aop aom cm v5 0 THS4551
Vp vp 0 12.6
Raint1 aom afbm 22
Vdds dds0 0 DC 0.3 AC 1
Raiso2 afbm aadc_m 4.32
R31 lp1 lp2 330
Rai2 lowbuf aim 1k
R34 srcfb 0 1k
Caflt2 aadc_m 0 330p
X7B low lowbuf lowbuf vp vn OPA2810
Rbi2 tia bim 1k
Cfbb1 bfbm bip 100p
Cbadc2 badc_m 0 16p
R33 excite srcfb 5k
Cbflt1 badc_p 0 330p
Cbdiff badc_p badc_m 3.3n
Cadiff aadc_p aadc_m 3.3n
Rbi1 lowbuf bip 1k
Raiso1 afbp aadc_p 4.32
Rbiso2 bfbm badc_m 4.32
Rai1 highbuf aip 1k
CF low tia 0.00000000001
Caadc1 aadc_p 0 16p
Rbint1 bom bfbm 22
Xb bip bim bop bom cm v5 0 THS4551
Caflt1 aadc_p 0 330p
Cfbb2 bfbp bim 100p
Raf1 afbm aip 1k
Rdds dds0 dds 200
V5 v5 0 5.25
Raf2 afbp aim 1k
RG source hi 5000
Caadc2 aadc_m 0 16p
Rbiso1 bfbp badc_p 4.32
Cfba1 afbm aip 100p
Cfixture hi low 0.0000000001
Itest hi low PULSE(0 1u 1u 1n 1n 5u 12u)
.control
set klu
optran 1 0 0 0 0 0
set filetype=ascii
set numdgt=17
op
write init-corner_cf10_cp100_afe12.6_fda5.25-order0.raw all
quit
.endc
.end
