RevC exact full chain; official models; real FDA bias and ADC RC loads
.include models/opa2810_a.lib
.include models/opa810_a.lib
.include models/ths4551.lib
.options reltol=1e-5 abstol=1e-12 vntol=1e-7 method=gear
.include final-seed.inc
Cbadc1 badc_p 0 16p
Rbf2 bfbp bim 1k
C35 lp2 0 1n
RDUT hi low 5000
R32 acin 0 100k
Rbf1 bfbm bip 1k
Raint2 aop afbp 22
C34 lp1 0 1n
R30 dds lp1 330
Cbflt2 badc_m 0 330p
X5 acin srcfb excite vp vn OPA810
C36 lp2 acin 1u
Cfba2 afbp aim 100p
Vcm cm 0 2.048
X6B hi highbuf highbuf vp vn OPA2810
RF low tia 5000
X7A 0 low tia vp vn OPA2810
X6A excite source source vp vn OPA2810
Rbint2 bop bfbp 22
Vn vn 0 -12
Xa aip aim aop aom cm v5 0 THS4551
Vp vp 0 12
Raint1 aom afbm 22
Vdds dds0 0 DC 0.3 AC 1 SIN(0.3 0.3 50k)
Raiso2 afbm aadc_m 4.32
R31 lp1 lp2 330
Rai2 lowbuf aim 1k
R34 srcfb 0 1k
Caflt2 aadc_m 0 330p
X7B low lowbuf lowbuf vp vn OPA2810
Rbi2 tia bim 1k
Cfbb1 bfbm bip 100p
Cbadc2 badc_m 0 16p
R33 excite srcfb 5k
Cbflt1 badc_p 0 330p
Cbdiff badc_p badc_m 3.3n
Cadiff aadc_p aadc_m 3.3n
Rbi1 lowbuf bip 1k
Raiso1 afbp aadc_p 4.32
Rbiso2 bfbm badc_m 4.32
Rai1 highbuf aip 1k
CF low tia 10p
Caadc1 aadc_p 0 16p
Rbint1 bom bfbm 22
Xb bip bim bop bom cm v5 0 THS4551
Caflt1 aadc_p 0 330p
Cfbb2 bfbp bim 100p
Raf1 afbm aip 1k
Rdds dds0 dds 200
V5 v5 0 5
Raf2 afbp aim 1k
RG source hi 5000
Caadc2 aadc_m 0 16p
Rbiso1 bfbp badc_p 4.32
Cfba1 afbm aip 100p
.control
set klu
optran 1 0 0 0 0 0
set wr_singlescale
set wr_vecnames
set filetype=ascii
op
write revc_5k_resistor-selected_op.raw all
let ihload=(v(highbuf)-v(aip))/1000
let ilload=(v(lowbuf)-v(aim))/1000+(v(lowbuf)-v(bip))/1000
let itload=(v(tia)-v(low))/5000+(v(tia)-v(bim))/1000
let kh=(-i(v.x6b.x_h3.vh_h3))-ihload
let kl=(-i(v.x7b.x_h3.vh_h3))-ilload
let kt=(-i(v.x7a.x_h3.vh_h3))-itload
print v(source) v(hi) v(low) v(tia) v(highbuf) v(lowbuf) v(aip) v(aim) v(bip) v(bim) v(aop) v(aom) v(bop) v(bom) (-i(v.x6b.x_h3.vh_h3)) (-i(v.x7b.x_h3.vh_h3)) (-i(v.x7a.x_h3.vh_h3)) kh kl kt
wrdata revc_5k_resistor-selected_dc.dat v(source) v(hi) v(low) v(tia) v(highbuf) v(lowbuf) v(aip) v(aim) v(bip) v(bim) v(aop) v(aom) v(bop) v(bom) (-i(v.x6b.x_h3.vh_h3)) (-i(v.x7b.x_h3.vh_h3)) (-i(v.x7a.x_h3.vh_h3)) kh kl kt
ac dec 80 10 100Meg
let a=v(aadc_p)-v(aadc_m)
let b=v(badc_p)-v(badc_m)
let ratio=a/b
wrdata revc_5k_resistor-selected_ac.dat real(ratio) imag(ratio) mag(a) mag(b)
tran 10n 120u 0 10n
let a=v(aadc_p)-v(aadc_m)
let b=v(badc_p)-v(badc_m)
wrdata revc_5k_resistor-selected_tran.dat v(dds0) v(source) v(hi) v(low) v(tia) v(highbuf) v(lowbuf) v(aadc_p) v(aadc_m) v(badc_p) v(badc_m) a b
quit
.endc
.end
