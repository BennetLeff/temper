RevC exact full chain; official models; real FDA bias and ADC RC loads
.include models/opa2810_a.lib
.include models/opa810_a.lib
.include models/ths4551.lib
.options reltol=1e-5 abstol=1e-12 vntol=1e-7 method=gear
.include final-seed.inc
Rbf2 bfbp bim 1k
C36 lp2 acin 1u
Cfbb2 bfbp bim 100p
X6A excite source source vp vn OPA2810
Raiso1 afbp aadc_p 4.32
RG source hi 100
Rbf1 bfbm bip 1k
Cbdiff badc_p badc_m 3.3n
Raf2 afbp aim 1k
C34 lp1 0 1n
Rbiso1 bfbp badc_p 4.32
R32 acin 0 100k
Rdds dds0 dds 200
Caadc1 aadc_p 0 16p
Caflt2 aadc_m 0 330p
Rbint2 bop bfbp 22
Cadiff aadc_p aadc_m 3.3n
Chi hi 0 0.000000000000000000000001
Rbi1 lowbuf bip 1k
Vcm cm 0 2.048
Cfba1 afbm aip 100p
R31 lp1 lp2 330
Clo low 0 0.000000000000000000000001
Itest hi low PULSE(0 1u 1u 1n 1n 10u 30u)
X7A 0 low tia vp vn OPA2810
Rai1 highbuf aip 1k
Raint2 aop afbp 22
Cbflt2 badc_m 0 330p
V5 v5 0 5
Raf1 afbm aip 1k
Rbiso2 bfbm badc_m 4.32
R30 dds lp1 330
X6B hi highbuf highbuf vp vn OPA2810
C35 lp2 0 1n
Xa aip aim aop aom cm v5 0 THS4551
X5 acin srcfb excite vp vn OPA810
Xb bip bim bop bom cm v5 0 THS4551
Caflt1 aadc_p 0 330p
R34 srcfb 0 1k
Rai2 lowbuf aim 1k
CF low tia 100p
Cbadc1 badc_p 0 16p
RDUT hi low 10m
Caadc2 aadc_m 0 16p
Raiso2 afbm aadc_m 4.32
Cbflt1 badc_p 0 330p
Vp vp 0 12
Cfba2 afbp aim 100p
Vn vn 0 -12
Vdds dds0 0 DC 0.3 AC 1
Cbadc2 badc_m 0 16p
Cfbb1 bfbm bip 100p
Rbi2 tia bim 1k
Raint1 aom afbm 22
RF low tia 100
R33 excite srcfb 5k
Rbint1 bom bfbm 22
X7B low lowbuf lowbuf vp vn OPA2810
.control
set klu
optran 1 0 0 0 0 0
set filetype=ascii
set numdgt=17
op
write init-c100_short10m-order8.raw all
quit
.endc
.end
