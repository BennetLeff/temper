RevC exact full chain; official models; real FDA bias and ADC RC loads
.include models/opa2810_a.lib
.include models/opa810_a.lib
.include models/ths4551.lib
.options reltol=1e-5 abstol=1e-12 vntol=1e-7 method=gear
.include final-seed.inc
Vdds dds0 0 DC 0.3 AC 1 SIN(0.3 0.3 50k)
X7B low lowbuf lowbuf vp vn OPA2810
Cbadc2 badc_m 0 16p
Cadiff aadc_p aadc_m 3.3n
X6B hi highbuf highbuf vp vn OPA2810
Caflt2 aadc_m 0 330p
R33 excite srcfb 5k
C35 lp2 0 1n
Vn vn 0 -12
Raint2 aop afbp 22
Raiso1 afbp aadc_p 4.32
Xb bip bim bop bom cm v5 0 THS4551
Caflt1 aadc_p 0 330p
Rbi2 tia bim 1k
Rdds dds0 dds 200
Cbdiff badc_p badc_m 3.3n
Rbiso2 bfbm badc_m 4.32
Cfbb1 bfbm bip 100p
RDUT hi low 5000
Rbint2 bop bfbp 22
Rai1 highbuf aip 1k
Rbint1 bom bfbm 22
Raint1 aom afbm 22
Rbf2 bfbp bim 1k
Caadc2 aadc_m 0 16p
Cfbb2 bfbp bim 100p
RG source hi 5000
C36 lp2 acin 1u
Xa aip aim aop aom cm v5 0 THS4551
Caadc1 aadc_p 0 16p
Cfba1 afbm aip 100p
X7A 0 low tia vp vn OPA2810
Cbflt1 badc_p 0 330p
R32 acin 0 100k
X6A excite source source vp vn OPA2810
Cbflt2 badc_m 0 330p
X5 acin srcfb excite vp vn OPA810
Cbadc1 badc_p 0 16p
Raiso2 afbm aadc_m 4.32
Rai2 lowbuf aim 1k
V5 v5 0 5
Vcm cm 0 2.048
Cfba2 afbp aim 100p
Vp vp 0 12
RF low tia 5000
R30 dds lp1 330
Raf2 afbp aim 1k
R31 lp1 lp2 330
R34 srcfb 0 1k
Rbi1 lowbuf bip 1k
Rbf1 bfbm bip 1k
C34 lp1 0 1n
CF low tia 10p
Rbiso1 bfbp badc_p 4.32
Raf1 afbm aip 1k
.control
set klu
optran 1 0 0 0 0 0
set filetype=ascii
set numdgt=17
op
write newton-5k-order5.raw all
quit
.endc
.end
