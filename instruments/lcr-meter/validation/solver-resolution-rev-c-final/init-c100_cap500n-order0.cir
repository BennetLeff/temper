RevC exact full chain; official models; real FDA bias and ADC RC loads
.include models/opa2810_a.lib
.include models/opa810_a.lib
.include models/ths4551.lib
.options reltol=1e-5 abstol=1e-12 vntol=1e-7 method=gear
.include final-seed.inc
Cfbb2 bfbp bim 100p
Cfbb1 bfbm bip 100p
Cfba2 afbp aim 100p
Cfba1 afbm aip 100p
Cbadc2 badc_m 0 16p
Cbadc1 badc_p 0 16p
Cbdiff badc_p badc_m 3.3n
Cbflt2 badc_m 0 330p
Cbflt1 badc_p 0 330p
Rbiso2 bfbm badc_m 4.32
Rbiso1 bfbp badc_p 4.32
Xb bip bim bop bom cm v5 0 THS4551
Rbint2 bop bfbp 22
Rbint1 bom bfbm 22
Rbf2 bfbp bim 1k
Rbf1 bfbm bip 1k
Rbi2 tia bim 1k
Rbi1 lowbuf bip 1k
Caadc2 aadc_m 0 16p
Caadc1 aadc_p 0 16p
Cadiff aadc_p aadc_m 3.3n
Caflt2 aadc_m 0 330p
Caflt1 aadc_p 0 330p
Raiso2 afbm aadc_m 4.32
Raiso1 afbp aadc_p 4.32
Xa aip aim aop aom cm v5 0 THS4551
Raint2 aop afbp 22
Raint1 aom afbm 22
Raf2 afbp aim 1k
Raf1 afbm aip 1k
Rai2 lowbuf aim 1k
Rai1 highbuf aip 1k
X7A 0 low tia vp vn OPA2810
X7B low lowbuf lowbuf vp vn OPA2810
X6B hi highbuf highbuf vp vn OPA2810
CF low tia 100p
RF low tia 100
CDUT hi low 500n
RG source hi 100
X6A excite source source vp vn OPA2810
R34 srcfb 0 1k
R33 excite srcfb 5k
X5 acin srcfb excite vp vn OPA810
R32 acin 0 100k
C36 lp2 acin 1u
C35 lp2 0 1n
R31 lp1 lp2 330
C34 lp1 0 1n
R30 dds lp1 330
Rdds dds0 dds 200
Vdds dds0 0 DC 0.3 AC 1
Vcm cm 0 2.048
V5 v5 0 5
Vn vn 0 -12
Vp vp 0 12
Chi hi 0 0.000000000000000000000001
Clo low 0 0.000000000000000000000001
Itest hi low PULSE(0 1u 1u 1n 1n 10u 30u)
.control
set klu
optran 1 0 0 0 0 0
set filetype=ascii
set numdgt=17
op
write init-c100_cap500n-order0.raw all
quit
.endc
.end
