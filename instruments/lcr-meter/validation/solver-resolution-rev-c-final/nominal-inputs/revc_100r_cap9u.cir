RevC exact full chain; official models; real FDA bias and ADC RC loads
.include models/opa2810_a.lib
.include models/opa810_a.lib
.include models/ths4551.lib
.options reltol=1e-5 abstol=1e-12 vntol=1e-7 method=gear
.include offset-nodeset.inc
Vp vp 0 12
Vn vn 0 -12
V5 v5 0 5
Vcm cm 0 2.048
Vdds dds0 0 DC 0.3 AC 1 SIN(0.3 0.3 50k)
Rdds dds0 dds 200
R30 dds lp1 330
C34 lp1 0 1n
R31 lp1 lp2 330
C35 lp2 0 1n
C36 lp2 acin 1u
R32 acin 0 100k
X5 acin srcfb excite vp vn OPA810
R33 excite srcfb 5k
R34 srcfb 0 1k
X6A excite source source vp vn OPA2810
RG source hi 100
CDUT hi low 9u
RF low tia 100
CF low tia 100p
X6B hi highbuf highbuf vp vn OPA2810
X7B low lowbuf lowbuf vp vn OPA2810
X7A 0 low tia vp vn OPA2810
Rai1 highbuf aip 1k
Rai2 lowbuf aim 1k
Raf1 afbm aip 1k
Raf2 afbp aim 1k
Raint1 aom afbm 3.3
Raint2 aop afbp 3.3
Xa aip aim aop aom cm v5 0 THS4551
Raiso1 aop aadc_p 4.02
Raiso2 aom aadc_m 4.02
Caflt1 aadc_p 0 330p
Caflt2 aadc_m 0 330p
Cadiff aadc_p aadc_m 3.3n
Caadc1 aadc_p 0 16p
Caadc2 aadc_m 0 16p
Rbi1 lowbuf bip 1k
Rbi2 tia bim 1k
Rbf1 bfbm bip 1k
Rbf2 bfbp bim 1k
Rbint1 bom bfbm 3.3
Rbint2 bop bfbp 3.3
Xb bip bim bop bom cm v5 0 THS4551
Rbiso1 bop badc_p 4.02
Rbiso2 bom badc_m 4.02
Cbflt1 badc_p 0 330p
Cbflt2 badc_m 0 330p
Cbdiff badc_p badc_m 3.3n
Cbadc1 badc_p 0 16p
Cbadc2 badc_m 0 16p
.control
set klu
set wr_singlescale
set wr_vecnames
set filetype=ascii
op
write revc_100r_cap9u_op.raw all
let ihload=(v(highbuf)-v(aip))/1000
let ilload=(v(lowbuf)-v(aim))/1000+(v(lowbuf)-v(bip))/1000
let itload=(v(tia)-v(low))/100+(v(tia)-v(bim))/1000
let kh=(-i(v.x6b.x_h3.vh_h3))-ihload
let kl=(-i(v.x7b.x_h3.vh_h3))-ilload
let kt=(-i(v.x7a.x_h3.vh_h3))-itload
print v(source) v(hi) v(low) v(tia) v(highbuf) v(lowbuf) v(aip) v(aim) v(bip) v(bim) v(aop) v(aom) v(bop) v(bom) (-i(v.x6b.x_h3.vh_h3)) (-i(v.x7b.x_h3.vh_h3)) (-i(v.x7a.x_h3.vh_h3)) kh kl kt
wrdata revc_100r_cap9u_dc.dat v(source) v(hi) v(low) v(tia) v(highbuf) v(lowbuf) v(aip) v(aim) v(bip) v(bim) v(aop) v(aom) v(bop) v(bom) (-i(v.x6b.x_h3.vh_h3)) (-i(v.x7b.x_h3.vh_h3)) (-i(v.x7a.x_h3.vh_h3)) kh kl kt
ac dec 80 10 100Meg
let a=v(aadc_p)-v(aadc_m)
let b=v(badc_p)-v(badc_m)
let ratio=a/b
wrdata revc_100r_cap9u_ac.dat real(ratio) imag(ratio) mag(a) mag(b)
tran 10n 120u 0 10n
let a=v(aadc_p)-v(aadc_m)
let b=v(badc_p)-v(badc_m)
wrdata revc_100r_cap9u_tran.dat v(dds0) v(source) v(hi) v(low) v(tia) v(highbuf) v(lowbuf) v(aadc_p) v(aadc_m) v(badc_p) v(badc_m) a b
quit
.endc
.end
