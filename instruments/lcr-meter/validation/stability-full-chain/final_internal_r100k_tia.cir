RevC final exact full chain; official models; real FDA bias and ADC RC loads
.include ../../sources/ti/models/opa2810_a.lib
.include ../../sources/ti/models/opa810_a.lib
.include ../../sources/ti/models/ths4551.lib
.options reltol=1e-5 abstol=1e-12 vntol=1e-7 method=gear
.include ../solver-resolution-rev-c-final/final-seed.inc
.include OPA2810-internal-probe.lib
Cbadc1 badc_p 0 16p
Rbf2 bfbp bim 1k
C35 lp2 0 1n
R32 acin 0 100k
Rbf1 bfbm bip 1k
Raint2 aop afbp 22
C34 lp1 0 1n
R30 dds lp1 330
RF low tia 100000
Cbflt2 badc_m 0 330p
X5 acin srcfb excite vp vn OPA810
C36 lp2 acin 1u
Cfba2 afbp aim 100p
Vdds dds0 0 DC 0.3 AC 0
Vcm cm 0 2.048
X6B hi highbuf highbuf vp vn OPA2810
X6A excite source source vp vn OPA2810
Rbint2 bop bfbp 22
Vn vn 0 -12
Xa aip aim aop aom cm v5 0 THS4551
Vp vp 0 12
Raint1 aom afbm 22
Raiso2 afbm aadc_m 4.32
R31 lp1 lp2 330
Rai2 lowbuf aim 1k
R34 srcfb 0 1k
Caflt2 aadc_m 0 330p
X7B low lowbuf lowbuf vp vn OPA2810
Rbi2 tia bim 1k
Cfbb1 bfbm bip 100p
Cbadc2 badc_m 0 16p
R33 excite srcfb 5k
Cbflt1 badc_p 0 330p
Cbdiff badc_p badc_m 3.3n
Cadiff aadc_p aadc_m 3.3n
Rbi1 lowbuf bip 1k
Raiso1 afbp aadc_p 4.32
Rbiso2 bfbm badc_m 4.32
Rai1 highbuf aip 1k
Caadc1 aadc_p 0 16p
CF low tia 0.000000000005
Rbint1 bom bfbm 22
Xb bip bim bop bom cm v5 0 THS4551
Caflt1 aadc_p 0 330p
Cfbb2 bfbp bim 100p
X7A 0 low tia vp vn OPA2810_PROBE
Raf1 afbm aip 1k
Rdds dds0 dds 200
V5 v5 0 5
Raf2 afbp aim 1k
Caadc2 aadc_m 0 16p
Rbiso1 bfbp badc_p 4.32
RG source hi 100000
Cfba1 afbm aip 100p
RDUT hi low 100000
.control
set klu
optran 1 0 0 0 0 0
set wr_singlescale
set wr_vecnames
set numdgt=17
op
wrdata final_internal_r100k_tia_dc.dat v(x5.mid) v(x6a.mid) v(x6b.mid) v(x7a.mid) v(x7b.mid) v(xa.mid) v(xb.mid) v(acin)
ac dec 240 1 1G
let t=-v(x7a.n31014,x7a.n11991)/v(x7a.nprobe,x7a.n11991)
wrdata final_internal_r100k_tia_return.dat real(t) imag(t)
quit
.endc
.end
