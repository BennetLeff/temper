RevC final exact full chain; official models; real FDA bias and ADC RC loads
.include ../../sources/ti/models/opa2810_a.lib
.include ../../sources/ti/models/opa810_a.lib
.include ../../sources/ti/models/ths4551.lib
.options reltol=1e-5 abstol=1e-12 vntol=1e-7 method=gear
.include ../solver-resolution-rev-c-final/final-seed.inc
.nodeset v(probe_fp)=1.0228 v(probe_fm)=1.0228
Cfba2 afbp aim 100p
Xa probe_fp probe_fm aop aom cm v5 0 THS4551
Raint2 aop afbp 22
Rai1 highbuf aip 1k
RDUT hi low 100000
X7A 0 low tia vp vn OPA2810
Cbdiff badc_p badc_m 3.3n
Cstrayhi hi 0 0.000000000000000000000001
X6B hi highbuf highbuf vp vn OPA2810
Cbadc1 badc_p 0 16p
Rbint2 bop bfbp 22
Rbf1 bfbm bip 1k
Cfba1 afbm aip 100p
Caadc2 aadc_m 0 16p
Raiso1 afbp aadc_p 4.32
Caadc1 aadc_p 0 16p
Cbadc2 badc_m 0 16p
Raf2 afbp aim 1k
Rbiso1 bfbp badc_p 4.32
Cstraylo low 0 0.000000000000000000000001
Vp vp 0 12
C36 lp2 acin 1u
Caflt1 aadc_p 0 330p
Raiso2 afbm aadc_m 4.32
Iinj2 0 probe_fp DC 0 AC 0
R32 acin 0 100k
Rdds dds0 dds 200
R30 dds lp1 330
Xb bip bim bop bom cm v5 0 THS4551
Caflt2 aadc_m 0 330p
Raint1 aom afbm 22
Cbflt1 badc_p 0 330p
Cadiff aadc_p aadc_m 3.3n
Rbi1 lowbuf bip 1k
X5 acin srcfb excite vp vn OPA810
Rbf2 bfbp bim 1k
R34 srcfb 0 1k
CF low tia 0.000000000005
R33 excite srcfb 5k
C34 lp1 0 1n
Vn vn 0 -12
R31 lp1 lp2 330
Vdds dds0 0 DC 0.3 AC 0
Cfbb1 bfbm bip 100p
Iinj2m 0 probe_fm DC 0 AC 0
Iinj 0 aip DC 0 AC 0.5
C35 lp2 0 1n
Rbridgem aim probe_fm 10
V5 v5 0 5
RF low tia 100000
Cfbb2 bfbp bim 100p
Iinjm 0 aim DC 0 AC 0.5
Rbint1 bom bfbm 22
X7B low lowbuf lowbuf vp vn OPA2810
Rbi2 tia bim 1k
Rbridgep aip probe_fp 10
Cbflt2 badc_m 0 330p
Vcm cm 0 2.048
Rai2 lowbuf aim 1k
RG source hi 100000
Rbiso2 bfbm badc_m 4.32
X6A excite source source vp vn OPA2810
Raf1 afbm aip 1k
.control
set klu
optran 1 0 0 0 0 0
set filetype=ascii
set numdgt=17
op
write final_r100k_matched_fda_a_cm-order7.raw all
quit
.endc
.end
