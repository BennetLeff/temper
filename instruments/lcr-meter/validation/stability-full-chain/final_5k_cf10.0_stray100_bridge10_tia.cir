RevC final exact full chain; official models; real FDA bias and ADC RC loads
.include ../../sources/ti/models/opa2810_a.lib
.include ../../sources/ti/models/opa810_a.lib
.include ../../sources/ti/models/ths4551.lib
.options reltol=1e-5 abstol=1e-12 vntol=1e-7 method=gear
.include ../solver-resolution-rev-c-final/final-seed.inc
.nodeset v(probe_f)=0.000100193
RF low tia 5000
Cstrayhi hi 0 0.0000000001
Cbadc1 badc_p 0 16p
Cfbb1 bfbm bip 100p
R33 excite srcfb 5k
Rbiso1 bfbp badc_p 4.32
Cadiff aadc_p aadc_m 3.3n
Rdds dds0 dds 200
Iinj2 0 probe_f DC 0 AC 0
Xb bip bim bop bom cm v5 0 THS4551
Raf2 afbp aim 1k
X7A 0 probe_f tia vp vn OPA2810
Cbdiff badc_p badc_m 3.3n
Caadc2 aadc_m 0 16p
Raiso2 afbm aadc_m 4.32
Rbi1 lowbuf bip 1k
Iinj 0 low DC 0 AC 1
Xa aip aim aop aom cm v5 0 THS4551
Cbflt1 badc_p 0 330p
R32 acin 0 100k
Raint2 aop afbp 22
R34 srcfb 0 1k
Cfba2 afbp aim 100p
Rai2 lowbuf aim 1k
C35 lp2 0 1n
Rbf1 bfbm bip 1k
X7B low lowbuf lowbuf vp vn OPA2810
V5 v5 0 5
Rai1 highbuf aip 1k
Raf1 afbm aip 1k
Caflt1 aadc_p 0 330p
Rbiso2 bfbm badc_m 4.32
C36 lp2 acin 1u
C34 lp1 0 1n
RDUT hi low 5000
R31 lp1 lp2 330
Caadc1 aadc_p 0 16p
Cbflt2 badc_m 0 330p
Vn vn 0 -12
RG source hi 5000
Rbint2 bop bfbp 22
R30 dds lp1 330
Vdds dds0 0 DC 0.3 AC 0
Raiso1 afbp aadc_p 4.32
X5 acin srcfb excite vp vn OPA810
Rbridge low probe_f 10
Caflt2 aadc_m 0 330p
Cbadc2 badc_m 0 16p
CF low tia 0.00000000001
Rbi2 tia bim 1k
Cfbb2 bfbp bim 100p
X6B hi highbuf highbuf vp vn OPA2810
Cfba1 afbm aip 100p
Vcm cm 0 2.048
Raint1 aom afbm 22
Rbf2 bfbp bim 1k
Vp vp 0 12
Rbint1 bom bfbm 22
X6A excite source source vp vn OPA2810
Cstraylo low 0 0.0000000001
.control
set klu
optran 1 0 0 0 0 0
set wr_singlescale
set wr_vecnames
set numdgt=17
op
wrdata final_5k_cf10.0_stray100_bridge10_tia_dc.dat v(x5.mid) v(x6a.mid) v(x6b.mid) v(x7a.mid) v(x7b.mid) v(xa.mid) v(xb.mid) v(acin) v(source) v(hi) v(low) v(tia) v(highbuf) v(lowbuf) v(aop) v(aom) v(bop) v(bom)
ac dec 120 1 1G
let ve=v(low)
let vf=v(probe_f)
wrdata final_5k_cf10.0_stray100_bridge10_tia_e.dat real(ve) imag(ve) real(vf) imag(vf)
alter Iinj ac=0
alter Iinj2 ac=1
ac dec 120 1 1G
let ve=v(low)
let vf=v(probe_f)
wrdata final_5k_cf10.0_stray100_bridge10_tia_f.dat real(ve) imag(ve) real(vf) imag(vf)
quit
.endc
.end
