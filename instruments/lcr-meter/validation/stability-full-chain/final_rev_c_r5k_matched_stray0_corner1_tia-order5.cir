RevC final exact full chain; official models; real FDA bias and ADC RC loads
.include ../../sources/ti/models/opa2810_a.lib
.include ../../sources/ti/models/opa810_a.lib
.include ../../sources/ti/models/ths4551.lib
.options reltol=1e-5 abstol=1e-12 vntol=1e-7 method=gear
.include ../solver-resolution-rev-c-final/final-seed.inc
.nodeset v(probe_f)=0.000100193
X7B low lowbuf lowbuf vp vn OPA2810
Cbadc2 badc_m 0 16p
Cadiff aadc_p aadc_m 3.3n
X6B hi highbuf highbuf vp vn OPA2810
Caflt2 aadc_m 0 330p
R33 excite srcfb 5k
C35 lp2 0 1n
RF low tia 4995
Raint2 aop afbp 22
Raiso1 afbp aadc_p 4.32
Xb bip bim bop bom cm v5 0 THS4551
Caflt1 aadc_p 0 330p
Rbi2 tia bim 1k
Vn vn 0 -12.600000000000001
Rdds dds0 dds 200
Cbdiff badc_p badc_m 3.3n
Rbiso2 bfbm badc_m 4.32
Cfbb1 bfbm bip 100p
RDUT hi low 5000
X7A 0 probe_f tia vp vn OPA2810
Cstraylo low 0 0.000000000000000000000001
V5 v5 0 5.25
Rbint2 bop bfbp 22
Rai1 highbuf aip 1k
Vdds dds0 0 DC 0.3 AC 0
Rbint1 bom bfbm 22
Raint1 aom afbm 22
Rbf2 bfbp bim 1k
Caadc2 aadc_m 0 16p
Cfbb2 bfbp bim 100p
C36 lp2 acin 1u
Xa aip aim aop aom cm v5 0 THS4551
Vp vp 0 12.600000000000001
Caadc1 aadc_p 0 16p
Rbridge low probe_f 100
Cfba1 afbm aip 100p
Cbflt1 badc_p 0 330p
R32 acin 0 100k
X6A excite source source vp vn OPA2810
Iinj2 0 probe_f DC 0 AC 0
Cbflt2 badc_m 0 330p
X5 acin srcfb excite vp vn OPA810
Cbadc1 badc_p 0 16p
Raiso2 afbm aadc_m 4.32
RG source hi 5004.999999999999
Rai2 lowbuf aim 1k
Iinj 0 low DC 0 AC 1
Vcm cm 0 2.048
Cfba2 afbp aim 100p
R30 dds lp1 330
Raf2 afbp aim 1k
R31 lp1 lp2 330
R34 srcfb 0 1k
CF low tia 0.0000000000105
Rbi1 lowbuf bip 1k
Rbf1 bfbm bip 1k
C34 lp1 0 1n
Cstrayhi hi 0 0.000000000000000000000001
Rbiso1 bfbp badc_p 4.32
Raf1 afbm aip 1k
.control
set klu
optran 1 0 0 0 0 0
set filetype=ascii
set numdgt=17
op
write final_rev_c_r5k_matched_stray0_corner1_tia-order5.raw all
quit
.endc
.end
