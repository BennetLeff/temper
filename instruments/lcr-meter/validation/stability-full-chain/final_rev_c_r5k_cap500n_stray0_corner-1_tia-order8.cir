RevC final exact full chain; official models; real FDA bias and ADC RC loads
.include ../../sources/ti/models/opa2810_a.lib
.include ../../sources/ti/models/opa810_a.lib
.include ../../sources/ti/models/ths4551.lib
.options reltol=1e-5 abstol=1e-12 vntol=1e-7 method=gear
.include ../solver-resolution-rev-c-final/final-seed.inc
.nodeset v(probe_f)=0.000100193
Rbf2 bfbp bim 1k
C36 lp2 acin 1u
Cfbb2 bfbp bim 100p
Vn vn 0 -11.399999999999999
Iinj2 0 probe_f DC 0 AC 0
X6A excite source source vp vn OPA2810
Raiso1 afbp aadc_p 4.32
Rbf1 bfbm bip 1k
Cstrayhi hi 0 0.000000000000000000000001
Cbdiff badc_p badc_m 3.3n
Raf2 afbp aim 1k
V5 v5 0 4.75
RF low tia 5004.999999999999
C34 lp1 0 1n
Iinj 0 low DC 0 AC 1
Rbridge low probe_f 100
Rbiso1 bfbp badc_p 4.32
R32 acin 0 100k
Cstraylo low 0 0.000000000000000000000001
Rdds dds0 dds 200
Caadc1 aadc_p 0 16p
Caflt2 aadc_m 0 330p
RG source hi 4995
Rbint2 bop bfbp 22
Cadiff aadc_p aadc_m 3.3n
Rbi1 lowbuf bip 1k
Vcm cm 0 2.048
Cfba1 afbm aip 100p
R31 lp1 lp2 330
CDUT hi low 500n
X7A 0 probe_f tia vp vn OPA2810
Vp vp 0 11.399999999999999
Rai1 highbuf aip 1k
Raint2 aop afbp 22
Cbflt2 badc_m 0 330p
Vdds dds0 0 DC 0.3 AC 0
Raf1 afbm aip 1k
Rbiso2 bfbm badc_m 4.32
R30 dds lp1 330
X6B hi highbuf highbuf vp vn OPA2810
C35 lp2 0 1n
Xa aip aim aop aom cm v5 0 THS4551
X5 acin srcfb excite vp vn OPA810
Xb bip bim bop bom cm v5 0 THS4551
CF low tia 0.0000000000095
Caflt1 aadc_p 0 330p
R34 srcfb 0 1k
Rai2 lowbuf aim 1k
Cbadc1 badc_p 0 16p
Caadc2 aadc_m 0 16p
Raiso2 afbm aadc_m 4.32
Cbflt1 badc_p 0 330p
Cfba2 afbp aim 100p
Cbadc2 badc_m 0 16p
Cfbb1 bfbm bip 100p
Rbi2 tia bim 1k
Raint1 aom afbm 22
R33 excite srcfb 5k
Rbint1 bom bfbm 22
X7B low lowbuf lowbuf vp vn OPA2810
.control
set klu
optran 1 0 0 0 0 0
set filetype=ascii
set numdgt=17
op
write final_rev_c_r5k_cap500n_stray0_corner-1_tia-order8.raw all
quit
.endc
.end
