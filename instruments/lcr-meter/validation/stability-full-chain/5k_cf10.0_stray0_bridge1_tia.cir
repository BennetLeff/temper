RevB exact full chain; official models; real FDA bias and ADC RC loads
.include ../../sources/ti/models/opa2810_a.lib
.include ../../sources/ti/models/opa810_a.lib
.include ../../sources/ti/models/ths4551.lib
.options reltol=1e-5 abstol=1e-12 vntol=1e-7 method=gear
.include seed-resistive.inc
Vp vp 0 12
Vn vn 0 -12
V5 v5 0 5
Vcm cm 0 2.048
Vdds dds0 0 DC 0.3 AC 0
Rdds dds0 dds 200
R30 dds lp1 330
C34 lp1 0 1n
R31 lp1 lp2 330
C35 lp2 0 1n
C36 lp2 acin 1u
R32 acin 0 100k
X5 acin srcfb excite vp vn OPA810
R33 excite srcfb 5k
R34 srcfb 0 1k
X6A excite source source vp vn OPA2810
RG source hi 5000
RDUT hi low 5000
RF low tia 5000
CF low tia 0.00000000001
X6B hi highbuf highbuf vp vn OPA2810
X7B low lowbuf lowbuf vp vn OPA2810
X7A 0 probe_f tia vp vn OPA2810
Rai1 highbuf aip 1k
Rai2 lowbuf aim 1k
Raf1 afbm aip 1k
Raf2 afbp aim 1k
Raint1 aom afbm 3.3
Raint2 aop afbp 3.3
Xa aip aim aop aom cm v5 0 THS4551
Raiso1 aop aadc_p 4.02
Raiso2 aom aadc_m 4.02
Caflt1 aadc_p 0 330p
Caflt2 aadc_m 0 330p
Cadiff aadc_p aadc_m 3.3n
Caadc1 aadc_p 0 16p
Caadc2 aadc_m 0 16p
Rbi1 lowbuf bip 1k
Rbi2 tia bim 1k
Rbf1 bfbm bip 1k
Rbf2 bfbp bim 1k
Rbint1 bom bfbm 3.3
Rbint2 bop bfbp 3.3
Xb bip bim bop bom cm v5 0 THS4551
Rbiso1 bop badc_p 4.02
Rbiso2 bom badc_m 4.02
Cbflt1 badc_p 0 330p
Cbflt2 badc_m 0 330p
Cbdiff badc_p badc_m 3.3n
Cbadc1 badc_p 0 16p
Cbadc2 badc_m 0 16p
Cstraylo low 0 0.000000000000000000000001
Cstrayhi hi 0 0.000000000000000000000001
Rbridge low probe_f 1
Iinj 0 low DC 0 AC 1
Iinj2 0 probe_f DC 0 AC 0
.nodeset v(probe_f)=0.000100193
.control
set klu
set wr_singlescale
set wr_vecnames
set numdgt=17
op
wrdata 5k_cf10.0_stray0_bridge1_tia_dc.dat v(x5.mid) v(x6a.mid) v(x6b.mid) v(x7a.mid) v(x7b.mid) v(xa.mid) v(xb.mid) v(acin) v(source) v(hi) v(low) v(tia) v(highbuf) v(lowbuf) v(aop) v(aom) v(bop) v(bom)
ac dec 120 1 1G
let ve=v(low)
let vf=v(probe_f)
wrdata 5k_cf10.0_stray0_bridge1_tia_e.dat real(ve) imag(ve) real(vf) imag(vf)
alter Iinj ac=0
alter Iinj2 ac=1
ac dec 120 1 1G
let ve=v(low)
let vf=v(probe_f)
wrdata 5k_cf10.0_stray0_bridge1_tia_f.dat real(ve) imag(ve) real(vf) imag(vf)
quit
.endc
.end
