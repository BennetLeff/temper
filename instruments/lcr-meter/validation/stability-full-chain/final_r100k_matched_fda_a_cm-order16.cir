RevC final exact full chain; official models; real FDA bias and ADC RC loads
.include ../../sources/ti/models/opa2810_a.lib
.include ../../sources/ti/models/opa810_a.lib
.include ../../sources/ti/models/ths4551.lib
.options reltol=1e-5 abstol=1e-12 vntol=1e-7 method=gear
.include ../solver-resolution-rev-c-final/final-seed.inc
.nodeset v(probe_fp)=1.0228 v(probe_fm)=1.0228
Cadiff aadc_p aadc_m 3.3n
Cfba1 afbm aip 100p
CF low tia 0.000000000005
Xa probe_fp probe_fm aop aom cm v5 0 THS4551
Cbflt2 badc_m 0 330p
Xb bip bim bop bom cm v5 0 THS4551
Rbridgep aip probe_fp 10
Iinjm 0 aim DC 0 AC 0.5
Cbadc2 badc_m 0 16p
Cstrayhi hi 0 0.000000000000000000000001
V5 v5 0 5
X7A 0 low tia vp vn OPA2810
Raiso2 afbm aadc_m 4.32
Vn vn 0 -12
X6B hi highbuf highbuf vp vn OPA2810
Rbf1 bfbm bip 1k
X5 acin srcfb excite vp vn OPA810
RF low tia 100000
Rbf2 bfbp bim 1k
Iinj2 0 probe_fp DC 0 AC 0
RG source hi 100000
C34 lp1 0 1n
R32 acin 0 100k
Caadc1 aadc_p 0 16p
Rbint1 bom bfbm 22
R33 excite srcfb 5k
Raf2 afbp aim 1k
C36 lp2 acin 1u
Cfbb2 bfbp bim 100p
Raint1 aom afbm 22
Rbiso1 bfbp badc_p 4.32
RDUT hi low 100000
Caflt2 aadc_m 0 330p
Iinj2m 0 probe_fm DC 0 AC 0
Raiso1 afbp aadc_p 4.32
Iinj 0 aip DC 0 AC 0.5
Rdds dds0 dds 200
C35 lp2 0 1n
Cbdiff badc_p badc_m 3.3n
Raint2 aop afbp 22
Raf1 afbm aip 1k
R31 lp1 lp2 330
Cbadc1 badc_p 0 16p
X7B low lowbuf lowbuf vp vn OPA2810
Cstraylo low 0 0.000000000000000000000001
Rai1 highbuf aip 1k
R34 srcfb 0 1k
Cfba2 afbp aim 100p
Rbi1 lowbuf bip 1k
Rbint2 bop bfbp 22
Vdds dds0 0 DC 0.3 AC 0
Rbridgem aim probe_fm 10
Cbflt1 badc_p 0 330p
Cfbb1 bfbm bip 100p
Vcm cm 0 2.048
Rbiso2 bfbm badc_m 4.32
X6A excite source source vp vn OPA2810
Caflt1 aadc_p 0 330p
Rbi2 tia bim 1k
Caadc2 aadc_m 0 16p
Rai2 lowbuf aim 1k
R30 dds lp1 330
Vp vp 0 12
.control
set klu
optran 1 0 0 0 0 0
set filetype=ascii
set numdgt=17
op
write final_r100k_matched_fda_a_cm-order16.raw all
quit
.endc
.end
