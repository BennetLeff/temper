RevE codec front end: TAC5112 DAC -> OPA810 difference stage -> TIDA core -> 1k/1k attenuators -> AC coupling -> codec inputs
.include ../../sources/ti/models/opa2810_a.lib
.include ../../sources/ti/models/opa810_a.lib
.options reltol=1e-5 abstol=1e-12 vntol=1e-7 method=gear
.include codec-seed.inc
* TAC5112 line outputs: 1.65 V common mode (datasheet 6.x), 10 ohm output resistance ASSUMED
* Difference stage, gain 2.0k/2.2k, pole 295 kHz; DC coupled (no settle), rejects the 1.65 V common mode
* Codec inputs (AC-coupled differential, 40 kOhm wideband setting, CM_TOL 01): CH1 = highbuf - lowbuf,
* CH2 = tia - lowbuf. Each leg: 1k/1k divider, 560 pF anti-alias, 1 uF coupling, BAT54S clamp (10 pF),
* 470 ohm series, pin = 40 kOhm to the internal common mode plus 10 pF (pin capacitance ASSUMED).
.nodeset v(probe_f)=0.000654719
Vp vp 0 12
Vn vn 0 -12
V5 v5 0 5
Vdacp dacp0 0 DC 1.65 AC 0
Vdacm dacm0 0 DC 1.65 AC 0
Rdacp dacp0 dacp 10
Rdacm dacm0 dacm 10
Rsa dacp acin 2.2k
Rsb acin 0 2.0k
Csb acin 0 270p
Rsc dacm srcfb 2.2k
Rsf excite srcfb 2.0k
Csf excite srcfb 270p
X5 acin srcfb excite vp vn OPA810
X6A excite source source vp vn OPA2810
RG srcbus hi 5000.075
Cng low 0 100p
Cxg_sum sum 0 0.9404p
Cxg_low low 0 7.4542p
Cxg_tia tia 0 9.0305p
Cxg_hi hi 0 12.9295p
Cxg_ru0 ru0 0 2.0765p
Cxg_ru2 ru2 0 2.7261p
Cxg_lowbuf lowbuf 0 1.9758p
Cxg_highbuf highbuf 0 1.6442p
Cxg_source srcbus 0 9.3792p
Cxg_rgu0 rgu0 0 0.9896p
Cxg_rgu2 rgu2 0 0.9894p
Cxg_srcdrv source 0 1.2808p
Cxg_hpot hpot 0 8.8664p
Cxg_lpot lpot 0 10.8626p
Cxg_refa refa 0 0.9089p
Cxm_sum_low sum low 0.0622p
Cxm_sum_tia sum tia 0.2013p
Cxm_sum_ru0 sum ru0 0.0861p
Cxm_sum_ru2 sum ru2 0.0973p
Cxm_sum_lowbuf sum lowbuf 0.0179p
Cxm_sum_lpot sum lpot 0.0025p
Cxm_low_tia low tia 0.0104p
Cxm_low_hi low hi 0.0166p
Cxm_low_lowbuf low lowbuf 0.0038p
Cxm_low_highbuf low highbuf 0.0012p
Cxm_low_source low srcbus 0.0988p
Cxm_low_hpot low hpot 0.0014p
Cxm_low_lpot low lpot 0.1373p
Cxm_low_refa low refa 0.0512p
Cxm_tia_hi tia hi 0.0011p
Cxm_tia_ru0 tia ru0 0.3183p
Cxm_tia_ru2 tia ru2 0.1297p
Cxm_tia_lowbuf tia lowbuf 0.0074p
Cxm_tia_highbuf tia highbuf 0.1415p
Cxm_tia_source tia srcbus 0.0523p
Cxm_hi_ru2 hi ru2 0.0023p
Cxm_hi_source hi srcbus 0.0794p
Cxm_hi_rgu0 hi rgu0 0.0511p
Cxm_hi_rgu2 hi rgu2 0.0513p
Cxm_hi_hpot hi hpot 0.2410p
Cxm_hi_lpot hi lpot 0.0036p
Cxm_hi_refa hi refa 0.0023p
Cxm_ru0_ru2 ru0 ru2 0.5693p
Cxm_ru0_source ru0 srcbus 0.0037p
Cxm_ru2_source ru2 srcbus 0.0985p
Cxm_lowbuf_highbuf lowbuf highbuf 0.0276p
Cxm_lowbuf_lpot lowbuf lpot 0.0895p
Cxm_highbuf_srcdrv highbuf source 0.0042p
Cxm_highbuf_hpot highbuf hpot 0.0997p
Cxm_source_rgu0 srcbus rgu0 0.0018p
Cxm_source_rgu2 srcbus rgu2 0.0018p
Cxm_source_srcdrv srcbus source 0.0020p
Cxm_source_lpot srcbus lpot 0.0122p
Cxm_srcdrv_hpot source hpot 0.0656p
Cxm_srcdrv_lpot source lpot 0.0451p
Cxm_hpot_lpot hpot lpot 0.0116p
Ru0 sum ru0 100
Cocf0 ru0 tia 0.3p
Ccf0 ru0 0 1p
Rgu0 hi rgu0 100
Cocs0 rgu0 srcbus 0.3p
Ccs0 rgu0 0 1p
Cpp0 srcbus ru0 0.5p
Cppx0 rgu0 tia 0.5p
Ru2 sum ru2 100000
Cocf2 ru2 tia 0.3p
Ccf2 ru2 0 1p
Rgu2 hi rgu2 100000
Cocs2 rgu2 srcbus 0.3p
Ccs2 rgu2 0 1p
Cpp2 srcbus ru2 0.5p
Cppx2 rgu2 tia 0.5p
Ccsel_t tia 0 1p
Ccsel_s srcbus 0 1p
Cppsel srcbus tia 0.5p
R105 hi hpot 1k
R106 low lpot 1k
R107 refa low 1k
Cc4h hi 0 1p
Cc4r refa 0 1p
Rk4 hi k4m 0.075
Lk4 k4m refa 10n
RDUT hi low 1e12
RF sum rf_end 5000.075
CF sum rf_end 0.000000000000000000000001
X6B hpot highbuf probe_f vp vn OPA2810
X7B lpot lowbuf lowbuf vp vn OPA2810
X7A 0 sum tia vp vn OPA2810
Vvcm vcm 0 1.375
Ra1s highbuf a1 1k
Ra1g a1 0 1k
Ca1aa a1 0 560p
Ca1c a1 a1c 1u
Ca1cl a1c 0 10p
Ra1p a1c a1pin 470
Ra1in a1pin vcm 40k
Ca1pin a1pin 0 10p
Ra2s lowbuf a2 1k
Ra2g a2 0 1k
Ca2aa a2 0 560p
Ca2c a2 a2c 1u
Ca2cl a2c 0 10p
Ra2p a2c a2pin 470
Ra2in a2pin vcm 40k
Ca2pin a2pin 0 10p
Rb1s tia b1 1k
Rb1g b1 0 1k
Cb1aa b1 0 560p
Cb1c b1 b1c 1u
Cb1cl b1c 0 10p
Rb1p b1c b1pin 470
Rb1in b1pin vcm 40k
Cb1pin b1pin 0 10p
Rb2s lowbuf b2 1k
Rb2g b2 0 1k
Cb2aa b2 0 560p
Cb2c b2 b2c 1u
Cb2cl b2c 0 10p
Rb2p b2c b2pin 470
Rb2in b2pin vcm 40k
Cb2pin b2pin 0 10p
Rsrciso source srcbus 47
Risolo low sum 22
Cstraylo low 0 0.000000000000000000000001
Cstrayhi hi 0 0.000000000000000000000001
Rbridge highbuf probe_f 0.01
Iinj 0 highbuf DC 0 AC 1
Iinj2 0 probe_f DC 0 AC 0
Clocal sum local_cf_out 0.0000000001
Llocal local_cf_out tia 0.00000000504
Lfeedback rf_end tia 0.00000007441
.control
set klu
optran 1 0 0 0 0 0
set wr_singlescale
set wr_vecnames
set numdgt=17
op
wrdata final_kelvinrelay_r5k_open_nocable_stray0_risolo22_bnom_nom_k4closed_cng100_srciso47_kelvin_caplead5.04_local100_lead74.41_high_dc.dat v(x5.mid) v(x6a.mid) v(x6b.mid) v(x7a.mid) v(x7b.mid) v(excite) v(source) v(hi) v(low) v(tia) v(highbuf) v(lowbuf)
ac dec 120 1 1G
let ve=v(highbuf)
let vf=v(probe_f)
wrdata final_kelvinrelay_r5k_open_nocable_stray0_risolo22_bnom_nom_k4closed_cng100_srciso47_kelvin_caplead5.04_local100_lead74.41_high_e.dat real(ve) imag(ve) real(vf) imag(vf)
alter Iinj ac=0
alter Iinj2 ac=1
ac dec 120 1 1G
let ve=v(highbuf)
let vf=v(probe_f)
wrdata final_kelvinrelay_r5k_open_nocable_stray0_risolo22_bnom_nom_k4closed_cng100_srciso47_kelvin_caplead5.04_local100_lead74.41_high_f.dat real(ve) imag(ve) real(vf) imag(vf)
quit
.endc
.end
