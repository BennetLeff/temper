RevC final exact full chain; official models; real FDA bias and ADC RC loads
.include ../../sources/ti/models/opa2810_a.lib
.include ../../sources/ti/models/opa810_a.lib
.include ../../sources/ti/models/ths4551.lib
.options reltol=1e-5 abstol=1e-12 vntol=1e-7 method=gear
.include ../solver-resolution-rev-c-final/final-seed.inc
.nodeset v(probe_fp)=1.0228 v(probe_fm)=1.0228
Cbflt2 badc_m 0 330p
Rbi1 lowbuf bip 1k
Rai2 lowbuf aim 1k
RG source hi 100000
X7B low lowbuf lowbuf vp vn OPA2810
Cbadc2 badc_m 0 16p
Rbridgep aip probe_fp 10
Cbflt1 badc_p 0 330p
X7A 0 low tia vp vn OPA2810
Vp vp 0 12
X6A excite source source vp vn OPA2810
Rbi2 tia bim 1k
Caflt1 aadc_p 0 330p
Raiso1 afbp aadc_p 4.32
Xa probe_fp probe_fm aop aom cm v5 0 THS4551
R30 dds lp1 330
CF low tia 0.000000000005
C34 lp1 0 1n
Rbint1 bom bfbm 22
X5 acin srcfb excite vp vn OPA810
X6B hi highbuf highbuf vp vn OPA2810
Caflt2 aadc_m 0 330p
RDUT hi low 100000
Cfbb2 bfbp bim 100p
Rbint2 bop bfbp 22
Cbadc1 badc_p 0 16p
C36 lp2 acin 1u
V5 v5 0 5
Cfbb1 bfbm bip 100p
Vn vn 0 -12
Raiso2 afbm aadc_m 4.32
Iinj 0 aip DC 0 AC 0.5
R34 srcfb 0 1k
Cstrayhi hi 0 0.000000000000000000000001
Rbiso1 bfbp badc_p 4.32
Iinj2m 0 probe_fm DC 0 AC 0
Rbf1 bfbm bip 1k
Rbiso2 bfbm badc_m 4.32
Rbf2 bfbp bim 1k
Xb bip bim bop bom cm v5 0 THS4551
C35 lp2 0 1n
Caadc1 aadc_p 0 16p
R32 acin 0 100k
Cfba1 afbm aip 100p
Cbdiff badc_p badc_m 3.3n
Raf1 afbm aip 1k
Raf2 afbp aim 1k
Raint2 aop afbp 22
Rai1 highbuf aip 1k
Cstraylo low 0 0.000000000000000000000001
Iinjm 0 aim DC 0 AC 0.5
Cadiff aadc_p aadc_m 3.3n
Vdds dds0 0 DC 0.3 AC 0
RF low tia 100000
Rdds dds0 dds 200
Vcm cm 0 2.048
Raint1 aom afbm 22
Iinj2 0 probe_fp DC 0 AC 0
R33 excite srcfb 5k
Cfba2 afbp aim 100p
R31 lp1 lp2 330
Rbridgem aim probe_fm 10
Caadc2 aadc_m 0 16p
.control
set klu
optran 1 0 0 0 0 0
set filetype=ascii
set numdgt=17
op
write final_r100k_matched_fda_a_cm-order18.raw all
quit
.endc
.end
