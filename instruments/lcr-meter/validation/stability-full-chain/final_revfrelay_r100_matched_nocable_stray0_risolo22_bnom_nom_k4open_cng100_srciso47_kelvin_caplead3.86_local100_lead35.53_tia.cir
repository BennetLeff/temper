RevE codec front end: TAC5112 DAC -> OPA810 difference stage -> TIDA core -> 1k/1k attenuators -> AC coupling -> codec inputs
.include ../../sources/ti/models/opa2810_a.lib
.include ../../sources/ti/models/opa810_a.lib
.options reltol=1e-5 abstol=1e-12 vntol=1e-7 method=gear
.include codec-seed.inc
* TAC5112 line outputs: 1.65 V common mode (datasheet 6.x), 10 ohm output resistance ASSUMED
* Difference stage, gain 2.0k/2.2k, pole 295 kHz; DC coupled (no settle), rejects the 1.65 V common mode
* Codec inputs (AC-coupled differential, 40 kOhm wideband setting, CM_TOL 01): CH1 = highbuf - lowbuf,
* CH2 = tia - lowbuf. Each leg: 1k/1k divider, 560 pF anti-alias, 1 uF coupling, BAT54S clamp (10 pF),
* 470 ohm series, pin = 40 kOhm to the internal common mode plus 10 pF (pin capacitance ASSUMED).
.nodeset v(probe_f)=0.000100193
Vp vp 0 12
Vn vn 0 -12
V5 v5 0 5
Vdacp dacp0 0 DC 1.65 AC 0
Vdacm dacm0 0 DC 1.65 AC 0
Rdacp dacp0 dacp 10
Rdacm dacm0 dacm 10
Rsa dacp acin 2.2k
Rsb acin 0 2.0k
Csb acin 0 270p
Rsc dacm srcfb 2.2k
Rsf excite srcfb 2.0k
Csf excite srcfb 270p
X5 acin srcfb excite vp vn OPA810
X6A excite source source vp vn OPA2810
RG srcbus hi 100.075
Cng low 0 100p
Cxg_sum sum 0 0.7527p
Cxg_low low 0 7.7410p
Cxg_tia tia 0 7.0189p
Cxg_hi hi 0 11.8128p
Cxg_ru1 ru1 0 1.3570p
Cxg_ru2 ru2 0 2.5217p
Cxg_lowbuf lowbuf 0 0.8258p
Cxg_highbuf highbuf 0 0.5086p
Cxg_source srcbus 0 6.0700p
Cxg_rgu1 rgu1 0 0.9696p
Cxg_rgu2 rgu2 0 0.9690p
Cxg_srcdrv source 0 0.5114p
Cxg_hpot hpot 0 4.4184p
Cxg_lpot lpot 0 5.1180p
Cxg_refa refa 0 0.9389p
Cxm_sum_low sum low 0.0554p
Cxm_sum_tia sum tia 0.1619p
Cxm_sum_ru1 sum ru1 0.0529p
Cxm_sum_ru2 sum ru2 0.0575p
Cxm_sum_lowbuf sum lowbuf 0.0020p
Cxm_sum_lpot sum lpot 0.0011p
Cxm_low_hi low hi 0.0011p
Cxm_low_lpot low lpot 0.0513p
Cxm_low_refa low refa 0.0517p
Cxm_tia_ru1 tia ru1 0.0119p
Cxm_tia_ru2 tia ru2 0.0990p
Cxm_tia_lowbuf tia lowbuf 0.0024p
Cxm_tia_lpot tia lpot 0.0013p
Cxm_hi_source hi srcbus 0.0529p
Cxm_hi_rgu1 hi rgu1 0.0512p
Cxm_hi_rgu2 hi rgu2 0.0511p
Cxm_hi_hpot hi hpot 0.0571p
Cxm_hi_lpot hi lpot 0.0014p
Cxm_hi_refa hi refa 0.0024p
Cxm_ru1_ru2 ru1 ru2 0.0029p
Cxm_lowbuf_lpot lowbuf lpot 0.0931p
Cxm_highbuf_srcdrv highbuf source 0.0017p
Cxm_highbuf_hpot highbuf hpot 0.0930p
Cxm_source_rgu1 srcbus rgu1 0.0019p
Cxm_source_rgu2 srcbus rgu2 0.0020p
Cxm_source_srcdrv srcbus source 0.0018p
Ru1 sum ru1 5000
Cocf1 ru1 tia 0.3p
Ccf1 ru1 0 1p
Rgu1 hi rgu1 5000
Cocs1 rgu1 srcbus 0.3p
Ccs1 rgu1 0 1p
Cpp1 srcbus ru1 0.5p
Cppx1 rgu1 tia 0.5p
Ru2 sum ru2 100000
Cocf2 ru2 tia 0.3p
Ccf2 ru2 0 1p
Rgu2 hi rgu2 100000
Cocs2 rgu2 srcbus 0.3p
Ccs2 rgu2 0 1p
Cpp2 srcbus ru2 0.5p
Cppx2 rgu2 tia 0.5p
Ccsel_t tia 0 1p
Ccsel_s srcbus 0 1p
Cppsel srcbus tia 0.5p
R105 hi hpot 1k
R106 low lpot 1k
R107 refa low 1k
Cc4h hi 0 1p
Cc4r refa 0 1p
Coc4 hi refa 0.3p
RDUT hi low 100
RF sum rf_end 100.075
CF sum rf_end 0.000000000000000000000001
X6B hpot highbuf highbuf vp vn OPA2810
X7B lpot lowbuf lowbuf vp vn OPA2810
X7A 0 probe_f tia vp vn OPA2810
Vvcm vcm 0 1.375
Ra1s highbuf a1 1k
Ra1g a1 0 1k
Ca1aa a1 0 560p
Ca1c a1 a1c 1u
Ca1cl a1c 0 10p
Ra1p a1c a1pin 470
Ra1in a1pin vcm 40k
Ca1pin a1pin 0 10p
Ra2s lowbuf a2 1k
Ra2g a2 0 1k
Ca2aa a2 0 560p
Ca2c a2 a2c 1u
Ca2cl a2c 0 10p
Ra2p a2c a2pin 470
Ra2in a2pin vcm 40k
Ca2pin a2pin 0 10p
Rb1s tia b1 1k
Rb1g b1 0 1k
Cb1aa b1 0 560p
Cb1c b1 b1c 1u
Cb1cl b1c 0 10p
Rb1p b1c b1pin 470
Rb1in b1pin vcm 40k
Cb1pin b1pin 0 10p
Rb2s lowbuf b2 1k
Rb2g b2 0 1k
Cb2aa b2 0 560p
Cb2c b2 b2c 1u
Cb2cl b2c 0 10p
Rb2p b2c b2pin 470
Rb2in b2pin vcm 40k
Cb2pin b2pin 0 10p
Rsrciso source srcbus 47
Risolo low sum 22
Cstraylo low 0 0.000000000000000000000001
Cstrayhi hi 0 0.000000000000000000000001
Rbridge sum probe_f 100
Iinj 0 sum DC 0 AC 1
Iinj2 0 probe_f DC 0 AC 0
Clocal sum local_cf_out 0.0000000001
Llocal local_cf_out tia 0.00000000386
Lfeedback rf_end tia 0.00000003553
.control
set klu
optran 1 0 0 0 0 0
set wr_singlescale
set wr_vecnames
set numdgt=17
op
wrdata final_revfrelay_r100_matched_nocable_stray0_risolo22_bnom_nom_k4open_cng100_srciso47_kelvin_caplead3.86_local100_lead35.53_tia_dc.dat v(x5.mid) v(x6a.mid) v(x6b.mid) v(x7a.mid) v(x7b.mid) v(excite) v(source) v(hi) v(low) v(tia) v(highbuf) v(lowbuf)
ac dec 120 1 1G
let ve=v(sum)
let vf=v(probe_f)
wrdata final_revfrelay_r100_matched_nocable_stray0_risolo22_bnom_nom_k4open_cng100_srciso47_kelvin_caplead3.86_local100_lead35.53_tia_e.dat real(ve) imag(ve) real(vf) imag(vf)
alter Iinj ac=0
alter Iinj2 ac=1
ac dec 120 1 1G
let ve=v(sum)
let vf=v(probe_f)
wrdata final_revfrelay_r100_matched_nocable_stray0_risolo22_bnom_nom_k4open_cng100_srciso47_kelvin_caplead3.86_local100_lead35.53_tia_f.dat real(ve) imag(ve) real(vf) imag(vf)
quit
.endc
.end
