RevC final exact full chain; official models; real FDA bias and ADC RC loads
.include ../../sources/ti/models/opa2810_a.lib
.include ../../sources/ti/models/opa810_a.lib
.include ../../sources/ti/models/ths4551.lib
.options reltol=1e-5 abstol=1e-12 vntol=1e-7 method=gear
.include ../solver-resolution-rev-c-final/final-seed.inc
.include OPA2810-internal-probe.lib
Raint1 aom afbm 22
RF low tia 100000
Rdds dds0 dds 200
Raf2 afbp aim 1k
Caadc2 aadc_m 0 16p
Raf1 afbm aip 1k
X7B low lowbuf lowbuf vp vn OPA2810
V5 v5 0 5
Rbint1 bom bfbm 22
C36 lp2 acin 1u
Rbf2 bfbp bim 1k
Rbi2 tia bim 1k
Vcm cm 0 2.048
C34 lp1 0 1n
Vdds dds0 0 DC 0.3 AC 0
Cbflt1 badc_p 0 330p
Caadc1 aadc_p 0 16p
Raint2 aop afbp 22
RG source hi 100000
CF low tia 0.000000000005
R34 srcfb 0 1k
Rbint2 bop bfbp 22
Rai2 lowbuf aim 1k
Cbadc1 badc_p 0 16p
R30 dds lp1 330
Cfbb1 bfbm bip 100p
Cbadc2 badc_m 0 16p
Rbiso2 bfbm badc_m 4.32
RDUT hi low 100000
Cbdiff badc_p badc_m 3.3n
X6A excite source source vp vn OPA2810
Caflt1 aadc_p 0 330p
Cfba2 afbp aim 100p
Xa aip aim aop aom cm v5 0 THS4551
R33 excite srcfb 5k
Raiso1 afbp aadc_p 4.32
X7A 0 low tia vp vn OPA2810
Xb bip bim bop bom cm v5 0 THS4551
Rbiso1 bfbp badc_p 4.32
Cadiff aadc_p aadc_m 3.3n
R32 acin 0 100k
X6B hi highbuf highbuf vp vn OPA2810_PROBE
Cfba1 afbm aip 100p
Vp vp 0 12
Caflt2 aadc_m 0 330p
Rai1 highbuf aip 1k
Vn vn 0 -12
Rbf1 bfbm bip 1k
C35 lp2 0 1n
Cfbb2 bfbp bim 100p
R31 lp1 lp2 330
Rbi1 lowbuf bip 1k
Raiso2 afbm aadc_m 4.32
Cbflt2 badc_m 0 330p
X5 acin srcfb excite vp vn OPA810
.control
set klu
optran 1 0 0 0 0 0
set filetype=ascii
set numdgt=17
op
write final_internal_r100k_high-order19.raw all
quit
.endc
.end
