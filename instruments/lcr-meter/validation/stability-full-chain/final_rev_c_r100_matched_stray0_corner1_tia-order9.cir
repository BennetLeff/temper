RevC final exact full chain; official models; real FDA bias and ADC RC loads
.include ../../sources/ti/models/opa2810_a.lib
.include ../../sources/ti/models/opa810_a.lib
.include ../../sources/ti/models/ths4551.lib
.options reltol=1e-5 abstol=1e-12 vntol=1e-7 method=gear
.include ../solver-resolution-rev-c-final/final-seed.inc
.nodeset v(probe_f)=0.000100193
Cbadc1 badc_p 0 16p
Rbf2 bfbp bim 1k
C35 lp2 0 1n
R32 acin 0 100k
Rbf1 bfbm bip 1k
Raint2 aop afbp 22
C34 lp1 0 1n
R30 dds lp1 330
Cbflt2 badc_m 0 330p
X5 acin srcfb excite vp vn OPA810
C36 lp2 acin 1u
Cfba2 afbp aim 100p
Vdds dds0 0 DC 0.3 AC 0
Vcm cm 0 2.048
X6B hi highbuf highbuf vp vn OPA2810
Cstraylo low 0 0.000000000000000000000001
X6A excite source source vp vn OPA2810
Rbint2 bop bfbp 22
Xa aip aim aop aom cm v5 0 THS4551
Raint1 aom afbm 22
Raiso2 afbm aadc_m 4.32
R31 lp1 lp2 330
Rai2 lowbuf aim 1k
R34 srcfb 0 1k
Rbridge low probe_f 100
X7A 0 probe_f tia vp vn OPA2810
RF low tia 99.9
Caflt2 aadc_m 0 330p
X7B low lowbuf lowbuf vp vn OPA2810
Rbi2 tia bim 1k
Cfbb1 bfbm bip 100p
Cbadc2 badc_m 0 16p
R33 excite srcfb 5k
Cbflt1 badc_p 0 330p
Cbdiff badc_p badc_m 3.3n
Cadiff aadc_p aadc_m 3.3n
Rbi1 lowbuf bip 1k
Raiso1 afbp aadc_p 4.32
RG source hi 100.1
Rbiso2 bfbm badc_m 4.32
Rai1 highbuf aip 1k
Caadc1 aadc_p 0 16p
V5 v5 0 5.25
Rbint1 bom bfbm 22
Iinj 0 low DC 0 AC 1
RDUT hi low 100
Xb bip bim bop bom cm v5 0 THS4551
Caflt1 aadc_p 0 330p
Cfbb2 bfbp bim 100p
CF low tia 0.00000000010500000000000001
Raf1 afbm aip 1k
Vn vn 0 -12.600000000000001
Rdds dds0 dds 200
Cstrayhi hi 0 0.000000000000000000000001
Vp vp 0 12.600000000000001
Raf2 afbp aim 1k
Caadc2 aadc_m 0 16p
Rbiso1 bfbp badc_p 4.32
Cfba1 afbm aip 100p
Iinj2 0 probe_f DC 0 AC 0
.control
set klu
optran 1 0 0 0 0 0
set filetype=ascii
set numdgt=17
op
write final_rev_c_r100_matched_stray0_corner1_tia-order9.raw all
quit
.endc
.end
