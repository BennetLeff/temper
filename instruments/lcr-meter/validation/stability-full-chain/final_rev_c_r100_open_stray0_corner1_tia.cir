RevC final exact full chain; official models; real FDA bias and ADC RC loads
.include ../../sources/ti/models/opa2810_a.lib
.include ../../sources/ti/models/opa810_a.lib
.include ../../sources/ti/models/ths4551.lib
.options reltol=1e-5 abstol=1e-12 vntol=1e-7 method=gear
.include ../solver-resolution-rev-c-final/final-seed.inc
.nodeset v(probe_f)=0.000100193
Cbflt2 badc_m 0 330p
Rai2 lowbuf aim 1k
Caflt2 aadc_m 0 330p
Rbiso2 bfbm badc_m 4.32
Vn vn 0 -12.600000000000001
Caadc2 aadc_m 0 16p
Iinj 0 low DC 0 AC 1
X5 acin srcfb excite vp vn OPA810
Rbi2 tia bim 1k
Cfba1 afbm aip 100p
R30 dds lp1 330
R31 lp1 lp2 330
Rbiso1 bfbp badc_p 4.32
Cstrayhi hi 0 0.000000000000000000000001
Raiso2 afbm aadc_m 4.32
CF low tia 0.00000000010500000000000001
Rbint1 bom bfbm 22
Xa aip aim aop aom cm v5 0 THS4551
Rdds dds0 dds 200
Raint1 aom afbm 22
Xb bip bim bop bom cm v5 0 THS4551
Caflt1 aadc_p 0 330p
Cfbb2 bfbp bim 100p
X6B hi highbuf highbuf vp vn OPA2810
RDUT hi low 1e12
Rbf1 bfbm bip 1k
R34 srcfb 0 1k
Cbflt1 badc_p 0 330p
Vp vp 0 12.600000000000001
Rbi1 lowbuf bip 1k
V5 v5 0 5.25
Cadiff aadc_p aadc_m 3.3n
RF low tia 99.9
C34 lp1 0 1n
Rai1 highbuf aip 1k
C36 lp2 acin 1u
Iinj2 0 probe_f DC 0 AC 0
Cbadc1 badc_p 0 16p
RG source hi 100.1
Vdds dds0 0 DC 0.3 AC 0
Cfbb1 bfbm bip 100p
Raf2 afbp aim 1k
R33 excite srcfb 5k
Raint2 aop afbp 22
Cbdiff badc_p badc_m 3.3n
X6A excite source source vp vn OPA2810
Cfba2 afbp aim 100p
X7B low lowbuf lowbuf vp vn OPA2810
C35 lp2 0 1n
Rbf2 bfbp bim 1k
Caadc1 aadc_p 0 16p
Vcm cm 0 2.048
Rbridge low probe_f 100
Rbint2 bop bfbp 22
X7A 0 probe_f tia vp vn OPA2810
Cstraylo low 0 0.000000000000000000000001
Cbadc2 badc_m 0 16p
Raiso1 afbp aadc_p 4.32
R32 acin 0 100k
Raf1 afbm aip 1k
.control
set klu
optran 1 0 0 0 0 0
set wr_singlescale
set wr_vecnames
set numdgt=17
op
wrdata final_rev_c_r100_open_stray0_corner1_tia_dc.dat v(x5.mid) v(x6a.mid) v(x6b.mid) v(x7a.mid) v(x7b.mid) v(xa.mid) v(xb.mid) v(acin) v(source) v(hi) v(low) v(tia) v(highbuf) v(lowbuf) v(aop) v(aom) v(bop) v(bom)
ac dec 120 1 1G
let ve=v(low)
let vf=v(probe_f)
wrdata final_rev_c_r100_open_stray0_corner1_tia_e.dat real(ve) imag(ve) real(vf) imag(vf)
alter Iinj ac=0
alter Iinj2 ac=1
ac dec 120 1 1G
let ve=v(low)
let vf=v(probe_f)
wrdata final_rev_c_r100_open_stray0_corner1_tia_f.dat real(ve) imag(ve) real(vf) imag(vf)
quit
.endc
.end
