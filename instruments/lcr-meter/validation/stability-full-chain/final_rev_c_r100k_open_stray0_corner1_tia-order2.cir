RevC final exact full chain; official models; real FDA bias and ADC RC loads
.include ../../sources/ti/models/opa2810_a.lib
.include ../../sources/ti/models/opa810_a.lib
.include ../../sources/ti/models/ths4551.lib
.options reltol=1e-5 abstol=1e-12 vntol=1e-7 method=gear
.include ../solver-resolution-rev-c-final/final-seed.inc
.nodeset v(probe_f)=0.000100193
Rbf2 bfbp bim 1k
Vdds dds0 0 DC 0.3 AC 0
Caflt1 aadc_p 0 330p
RDUT hi low 1e12
Cbadc1 badc_p 0 16p
Iinj 0 low DC 0 AC 1
Cstraylo low 0 0.000000000000000000000001
Cfbb2 bfbp bim 100p
Rbi2 tia bim 1k
Raiso2 afbm aadc_m 4.32
RG source hi 100099.99999999999
Raf1 afbm aip 1k
Caadc1 aadc_p 0 16p
Cbadc2 badc_m 0 16p
V5 v5 0 5.25
RF low tia 99900
Xb bip bim bop bom cm v5 0 THS4551
Cbflt1 badc_p 0 330p
Xa aip aim aop aom cm v5 0 THS4551
Cfba2 afbp aim 100p
Rdds dds0 dds 200
X5 acin srcfb excite vp vn OPA810
Raint1 aom afbm 22
Rbf1 bfbm bip 1k
Rbi1 lowbuf bip 1k
Vn vn 0 -12.600000000000001
Rbiso1 bfbp badc_p 4.32
Cbdiff badc_p badc_m 3.3n
Raiso1 afbp aadc_p 4.32
R31 lp1 lp2 330
Cfbb1 bfbm bip 100p
Rai2 lowbuf aim 1k
R34 srcfb 0 1k
X7B low lowbuf lowbuf vp vn OPA2810
X7A 0 probe_f tia vp vn OPA2810
Vp vp 0 12.600000000000001
Rbiso2 bfbm badc_m 4.32
Raint2 aop afbp 22
Cstrayhi hi 0 0.000000000000000000000001
C34 lp1 0 1n
Cfba1 afbm aip 100p
Caadc2 aadc_m 0 16p
X6A excite source source vp vn OPA2810
Iinj2 0 probe_f DC 0 AC 0
C36 lp2 acin 1u
Rbint2 bop bfbp 22
Cbflt2 badc_m 0 330p
CF low tia 0.00000000000525
R32 acin 0 100k
Caflt2 aadc_m 0 330p
Rbridge low probe_f 100
Rai1 highbuf aip 1k
C35 lp2 0 1n
X6B hi highbuf highbuf vp vn OPA2810
Cadiff aadc_p aadc_m 3.3n
Vcm cm 0 2.048
Raf2 afbp aim 1k
Rbint1 bom bfbm 22
R30 dds lp1 330
R33 excite srcfb 5k
.control
set klu
optran 1 0 0 0 0 0
set filetype=ascii
set numdgt=17
op
write final_rev_c_r100k_open_stray0_corner1_tia-order2.raw all
quit
.endc
.end
