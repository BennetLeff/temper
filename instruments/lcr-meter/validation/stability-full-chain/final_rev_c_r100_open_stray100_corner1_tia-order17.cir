RevC final exact full chain; official models; real FDA bias and ADC RC loads
.include ../../sources/ti/models/opa2810_a.lib
.include ../../sources/ti/models/opa810_a.lib
.include ../../sources/ti/models/ths4551.lib
.options reltol=1e-5 abstol=1e-12 vntol=1e-7 method=gear
.include ../solver-resolution-rev-c-final/final-seed.inc
.nodeset v(probe_f)=0.000100193
Cstraylo low 0 0.0000000001
Cbflt1 badc_p 0 330p
X6A excite source source vp vn OPA2810
Vn vn 0 -12.600000000000001
X7A 0 probe_f tia vp vn OPA2810
Caadc2 aadc_m 0 16p
CF low tia 0.00000000010500000000000001
Cfbb2 bfbp bim 100p
Raiso2 afbm aadc_m 4.32
Cfba1 afbm aip 100p
Raf1 afbm aip 1k
Cadiff aadc_p aadc_m 3.3n
Caflt1 aadc_p 0 330p
Rbf2 bfbp bim 1k
Rbf1 bfbm bip 1k
Raiso1 afbp aadc_p 4.32
Rbi2 tia bim 1k
Cbadc2 badc_m 0 16p
Vdds dds0 0 DC 0.3 AC 0
Raf2 afbp aim 1k
RG source hi 100.1
Vp vp 0 12.600000000000001
Rbint1 bom bfbm 22
Xb bip bim bop bom cm v5 0 THS4551
Caadc1 aadc_p 0 16p
Vcm cm 0 2.048
RF low tia 99.9
Raint1 aom afbm 22
R31 lp1 lp2 330
Rbiso2 bfbm badc_m 4.32
V5 v5 0 5.25
X6B hi highbuf highbuf vp vn OPA2810
Raint2 aop afbp 22
Rbridge low probe_f 100
Iinj 0 low DC 0 AC 1
R30 dds lp1 330
Cfbb1 bfbm bip 100p
RDUT hi low 1e12
Cbdiff badc_p badc_m 3.3n
C36 lp2 acin 1u
Cstrayhi hi 0 0.0000000001
C34 lp1 0 1n
Rai2 lowbuf aim 1k
Rbi1 lowbuf bip 1k
Cbflt2 badc_m 0 330p
Cfba2 afbp aim 100p
X5 acin srcfb excite vp vn OPA810
Rdds dds0 dds 200
Cbadc1 badc_p 0 16p
X7B low lowbuf lowbuf vp vn OPA2810
Rbiso1 bfbp badc_p 4.32
Caflt2 aadc_m 0 330p
Rbint2 bop bfbp 22
Xa aip aim aop aom cm v5 0 THS4551
R32 acin 0 100k
R34 srcfb 0 1k
Iinj2 0 probe_f DC 0 AC 0
Rai1 highbuf aip 1k
C35 lp2 0 1n
R33 excite srcfb 5k
.control
set klu
optran 1 0 0 0 0 0
set filetype=ascii
set numdgt=17
op
write final_rev_c_r100_open_stray100_corner1_tia-order17.raw all
quit
.endc
.end
