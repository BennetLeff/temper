RevC final exact full chain; official models; real FDA bias and ADC RC loads
.include ../../sources/ti/models/opa2810_a.lib
.include ../../sources/ti/models/opa810_a.lib
.include ../../sources/ti/models/ths4551.lib
.options reltol=1e-5 abstol=1e-12 vntol=1e-7 method=gear
.include ../solver-resolution-rev-c-final/final-seed.inc
.nodeset v(probe_f)=0.000100193
Vp vp 0 12
Vn vn 0 -12
V5 v5 0 5
Vcm cm 0 2.048
Vdds dds0 0 DC 0.3 AC 0
Rdds dds0 dds 200
R30 dds lp1 330
C34 lp1 0 1n
R31 lp1 lp2 330
C35 lp2 0 1n
C36 lp2 acin 1u
R32 acin 0 100k
X5 acin srcfb excite vp vn OPA810
R33 excite srcfb 5k
R34 srcfb 0 1k
X6A excite source source vp vn OPA2810
RG source hi 5000
Lwh0 hi h_n0 0.000000012625000000000002
Cwh0 h_n0 0 0.0000000000050500000000000005
Lwh1 h_n0 h_n1 0.000000012625000000000002
Cwh1 h_n1 0 0.0000000000050500000000000005
Lwh2 h_n1 h_n2 0.000000012625000000000002
Cwh2 h_n2 0 0.0000000000050500000000000005
Lwh3 h_n2 h_n3 0.000000012625000000000002
Cwh3 h_n3 0 0.0000000000050500000000000005
Lwh4 h_n3 h_n4 0.000000012625000000000002
Cwh4 h_n4 0 0.0000000000050500000000000005
Lwh5 h_n4 h_n5 0.000000012625000000000002
Cwh5 h_n5 0 0.0000000000050500000000000005
Lwh6 h_n5 h_n6 0.000000012625000000000002
Cwh6 h_n6 0 0.0000000000050500000000000005
Lwh7 h_n6 h_n7 0.000000012625000000000002
Cwh7 h_n7 0 0.0000000000050500000000000005
Lwh8 h_n7 h_n8 0.000000012625000000000002
Cwh8 h_n8 0 0.0000000000050500000000000005
Lwh9 h_n8 h_n9 0.000000012625000000000002
Cwh9 h_n9 0 0.0000000000050500000000000005
Lwh10 h_n9 h_n10 0.000000012625000000000002
Cwh10 h_n10 0 0.0000000000050500000000000005
Lwh11 h_n10 h_n11 0.000000012625000000000002
Cwh11 h_n11 0 0.0000000000050500000000000005
Lwh12 h_n11 h_n12 0.000000012625000000000002
Cwh12 h_n12 0 0.0000000000050500000000000005
Lwh13 h_n12 h_n13 0.000000012625000000000002
Cwh13 h_n13 0 0.0000000000050500000000000005
Lwh14 h_n13 h_n14 0.000000012625000000000002
Cwh14 h_n14 0 0.0000000000050500000000000005
Lwh15 h_n14 h_n15 0.000000012625000000000002
Cwh15 h_n15 0 0.0000000000050500000000000005
Lwh16 h_n15 h_n16 0.000000012625000000000002
Cwh16 h_n16 0 0.0000000000050500000000000005
Lwh17 h_n16 h_n17 0.000000012625000000000002
Cwh17 h_n17 0 0.0000000000050500000000000005
Lwh18 h_n17 h_n18 0.000000012625000000000002
Cwh18 h_n18 0 0.0000000000050500000000000005
Lwh19 h_n18 h_dut 0.000000012625000000000002
Cwh19 h_dut 0 0.0000000000050500000000000005
Lwl0 low l_n0 0.000000012625000000000002
Cwl0 l_n0 0 0.0000000000050500000000000005
Lwl1 l_n0 l_n1 0.000000012625000000000002
Cwl1 l_n1 0 0.0000000000050500000000000005
Lwl2 l_n1 l_n2 0.000000012625000000000002
Cwl2 l_n2 0 0.0000000000050500000000000005
Lwl3 l_n2 l_n3 0.000000012625000000000002
Cwl3 l_n3 0 0.0000000000050500000000000005
Lwl4 l_n3 l_n4 0.000000012625000000000002
Cwl4 l_n4 0 0.0000000000050500000000000005
Lwl5 l_n4 l_n5 0.000000012625000000000002
Cwl5 l_n5 0 0.0000000000050500000000000005
Lwl6 l_n5 l_n6 0.000000012625000000000002
Cwl6 l_n6 0 0.0000000000050500000000000005
Lwl7 l_n6 l_n7 0.000000012625000000000002
Cwl7 l_n7 0 0.0000000000050500000000000005
Lwl8 l_n7 l_n8 0.000000012625000000000002
Cwl8 l_n8 0 0.0000000000050500000000000005
Lwl9 l_n8 l_n9 0.000000012625000000000002
Cwl9 l_n9 0 0.0000000000050500000000000005
Lwl10 l_n9 l_n10 0.000000012625000000000002
Cwl10 l_n10 0 0.0000000000050500000000000005
Lwl11 l_n10 l_n11 0.000000012625000000000002
Cwl11 l_n11 0 0.0000000000050500000000000005
Lwl12 l_n11 l_n12 0.000000012625000000000002
Cwl12 l_n12 0 0.0000000000050500000000000005
Lwl13 l_n12 l_n13 0.000000012625000000000002
Cwl13 l_n13 0 0.0000000000050500000000000005
Lwl14 l_n13 l_n14 0.000000012625000000000002
Cwl14 l_n14 0 0.0000000000050500000000000005
Lwl15 l_n14 l_n15 0.000000012625000000000002
Cwl15 l_n15 0 0.0000000000050500000000000005
Lwl16 l_n15 l_n16 0.000000012625000000000002
Cwl16 l_n16 0 0.0000000000050500000000000005
Lwl17 l_n16 l_n17 0.000000012625000000000002
Cwl17 l_n17 0 0.0000000000050500000000000005
Lwl18 l_n17 l_n18 0.000000012625000000000002
Cwl18 l_n18 0 0.0000000000050500000000000005
Lwl19 l_n18 l_dut 0.000000012625000000000002
Cwl19 l_dut 0 0.0000000000050500000000000005
RDUT h_dut l_dut 5000
RF sum rf_end 5000
CF sum rf_end 0.000000000000000000000001
X6B hi highbuf highbuf vp vn OPA2810
X7B low lowbuf lowbuf vp vn OPA2810
X7A 0 probe_f tia vp vn OPA2810
Rai1 highbuf aip 1k
Rai2 lowbuf aim 1k
Raf1 afbm aip 1k
Raf2 afbp aim 1k
Raint1 aom afbm 22
Raint2 aop afbp 22
Xa aip aim aop aom cm v5 0 THS4551
Raiso1 afbp aadc_p 4.32
Raiso2 afbm aadc_m 4.32
Caflt1 aadc_p 0 330p
Caflt2 aadc_m 0 330p
Cadiff aadc_p aadc_m 3.3n
Caadc1 aadc_p 0 16p
Caadc2 aadc_m 0 16p
Rbi1 lowbuf bip 1k
Rbi2 tia bim 1k
Rbf1 bfbm bip 1k
Rbf2 bfbp bim 1k
Rbint1 bom bfbm 22
Rbint2 bop bfbp 22
Xb bip bim bop bom cm v5 0 THS4551
Rbiso1 bfbp badc_p 4.32
Rbiso2 bfbm badc_m 4.32
Cbflt1 badc_p 0 330p
Cbflt2 badc_m 0 330p
Cbdiff badc_p badc_m 3.3n
Cbadc1 badc_p 0 16p
Cbadc2 badc_m 0 16p
Cfba1 afbm aip 100p
Cfba2 afbp aim 100p
Cfbb1 bfbm bip 100p
Cfbb2 bfbp bim 100p
Risolo low sum 22
Cstraylo low 0 0.000000000000000000000001
Cstrayhi hi 0 0.000000000000000000000001
Rbridge sum probe_f 100
Iinj 0 sum DC 0 AC 1
Iinj2 0 probe_f DC 0 AC 0
Clocal sum local_cf_out 0.0000000001
Llocal local_cf_out tia 0.000000005
Lfeedback rf_end tia 0.00000010000000000000001
.control
set klu
optran 1 0 0 0 0 0
set filetype=ascii
set numdgt=17
op
write final_leads_r5k_matched_coax1m_risolo22_caplead5_local100_lead100_tia-order0.raw all
quit
.endc
.end
