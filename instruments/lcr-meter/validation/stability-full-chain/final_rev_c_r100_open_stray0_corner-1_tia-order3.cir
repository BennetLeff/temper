RevC final exact full chain; official models; real FDA bias and ADC RC loads
.include ../../sources/ti/models/opa2810_a.lib
.include ../../sources/ti/models/opa810_a.lib
.include ../../sources/ti/models/ths4551.lib
.options reltol=1e-5 abstol=1e-12 vntol=1e-7 method=gear
.include ../solver-resolution-rev-c-final/final-seed.inc
.nodeset v(probe_f)=0.000100193
Cbadc1 badc_p 0 16p
Cfbb1 bfbm bip 100p
R33 excite srcfb 5k
Rbiso1 bfbp badc_p 4.32
Cadiff aadc_p aadc_m 3.3n
Rdds dds0 dds 200
Iinj2 0 probe_f DC 0 AC 0
Xb bip bim bop bom cm v5 0 THS4551
Raf2 afbp aim 1k
X7A 0 probe_f tia vp vn OPA2810
Cbdiff badc_p badc_m 3.3n
Caadc2 aadc_m 0 16p
Raiso2 afbm aadc_m 4.32
Rbi1 lowbuf bip 1k
Iinj 0 low DC 0 AC 1
Xa aip aim aop aom cm v5 0 THS4551
Cbflt1 badc_p 0 330p
R32 acin 0 100k
Rbridge low probe_f 100
CF low tia 0.000000000095
Raint2 aop afbp 22
R34 srcfb 0 1k
Cfba2 afbp aim 100p
Rai2 lowbuf aim 1k
C35 lp2 0 1n
Rbf1 bfbm bip 1k
X7B low lowbuf lowbuf vp vn OPA2810
RG source hi 99.9
Rai1 highbuf aip 1k
Raf1 afbm aip 1k
Caflt1 aadc_p 0 330p
Rbiso2 bfbm badc_m 4.32
C36 lp2 acin 1u
C34 lp1 0 1n
R31 lp1 lp2 330
Caadc1 aadc_p 0 16p
Cbflt2 badc_m 0 330p
Vp vp 0 11.399999999999999
Rbint2 bop bfbp 22
RF low tia 100.1
Vn vn 0 -11.399999999999999
R30 dds lp1 330
Cstrayhi hi 0 0.000000000000000000000001
V5 v5 0 4.75
Vdds dds0 0 DC 0.3 AC 0
Cstraylo low 0 0.000000000000000000000001
Raiso1 afbp aadc_p 4.32
X5 acin srcfb excite vp vn OPA810
Caflt2 aadc_m 0 330p
Cbadc2 badc_m 0 16p
RDUT hi low 1e12
Rbi2 tia bim 1k
Cfbb2 bfbp bim 100p
X6B hi highbuf highbuf vp vn OPA2810
Cfba1 afbm aip 100p
Vcm cm 0 2.048
Raint1 aom afbm 22
Rbf2 bfbp bim 1k
Rbint1 bom bfbm 22
X6A excite source source vp vn OPA2810
.control
set klu
optran 1 0 0 0 0 0
set filetype=ascii
set numdgt=17
op
write final_rev_c_r100_open_stray0_corner-1_tia-order3.raw all
quit
.endc
.end
