RevE codec front end: TAC5112 DAC -> OPA810 difference stage -> TIDA core -> 1k/1k attenuators -> AC coupling -> codec inputs
.include ../../sources/ti/models/opa2810_a.lib
.include ../../sources/ti/models/opa810_a.lib
.options reltol=1e-5 abstol=1e-12 vntol=1e-7 method=gear
.include codec-seed.inc
* TAC5112 line outputs: 1.65 V common mode (datasheet 6.x), 10 ohm output resistance ASSUMED
* Difference stage, gain 2.0k/2.2k, pole 295 kHz; DC coupled (no settle), rejects the 1.65 V common mode
* Codec inputs (AC-coupled differential, 40 kOhm wideband setting, CM_TOL 01): CH1 = highbuf - lowbuf,
* CH2 = tia - lowbuf. Each leg: 1k/1k divider, 560 pF anti-alias, 1 uF coupling, BAT54S clamp (10 pF),
* 470 ohm series, pin = 40 kOhm to the internal common mode plus 10 pF (pin capacitance ASSUMED).
.nodeset v(probe_f)=0.000201502
Vp vp 0 12
Vn vn 0 -12
V5 v5 0 5
Vdacp dacp0 0 DC 1.65 AC 0
Vdacm dacm0 0 DC 1.65 AC 0
Rdacp dacp0 dacp 10
Rdacm dacm0 dacm 10
Rsa dacp acin 2.2k
Rsb acin 0 2.0k
Csb acin 0 270p
Rsc dacm srcfb 2.2k
Rsf excite srcfb 2.0k
Csf excite srcfb 270p
X5 acin srcfb excite vp vn OPA810
X6A excite source source vp vn OPA2810
RG srcbus hi 100000.075
Cng low 0 100p
Cxg_sum sum 0 0.8610p
Cxg_low low 0 14.4225p
Cxg_tia tia 0 14.0176p
Cxg_hi hi 0 19.3767p
Cxg_ru0 ru0 0 3.7255p
Cxg_ru1 ru1 0 3.3091p
Cxg_lowbuf lowbuf 0 1.9545p
Cxg_highbuf highbuf 0 0.9497p
Cxg_source srcbus 0 11.6806p
Cxg_rgu0 rgu0 0 2.5943p
Cxg_rgu1 rgu1 0 2.5945p
Cxg_srcdrv source 0 0.9289p
Cxg_hpot hpot 0 7.0076p
Cxg_lpot lpot 0 8.7596p
Cxg_refa refa 0 2.5380p
Cxm_sum_low sum low 0.1073p
Cxm_sum_tia sum tia 0.3977p
Cxm_sum_ru0 sum ru0 0.1033p
Cxm_sum_ru1 sum ru1 0.1036p
Cxm_sum_lowbuf sum lowbuf 0.0026p
Cxm_sum_lpot sum lpot 0.0015p
Cxm_low_tia low tia 0.0013p
Cxm_low_hi low hi 0.0013p
Cxm_low_lpot low lpot 0.1017p
Cxm_low_refa low refa 0.1024p
Cxm_tia_ru0 tia ru0 0.0039p
Cxm_tia_ru1 tia ru1 0.0204p
Cxm_tia_lowbuf tia lowbuf 0.0031p
Cxm_tia_lpot tia lpot 0.0016p
Cxm_hi_highbuf hi highbuf 0.0011p
Cxm_hi_source hi srcbus 0.1036p
Cxm_hi_rgu0 hi rgu0 0.1016p
Cxm_hi_rgu1 hi rgu1 0.1016p
Cxm_hi_hpot hi hpot 0.1091p
Cxm_hi_lpot hi lpot 0.0018p
Cxm_hi_refa hi refa 0.0030p
Cxm_ru0_ru1 ru0 ru1 0.0013p
Cxm_lowbuf_lpot lowbuf lpot 0.1464p
Cxm_highbuf_srcdrv highbuf source 0.0021p
Cxm_highbuf_hpot highbuf hpot 0.1439p
Cxm_source_rgu0 srcbus rgu0 0.0025p
Cxm_source_rgu1 srcbus rgu1 0.0025p
Cxm_source_srcdrv srcbus source 0.0022p
Cxm_srcdrv_hpot source hpot 0.0012p
Ru0 sum ru0 100
Cocf0 ru0 tia 2p
Ccf0 ru0 0 5p
Rgu0 hi rgu0 100
Cocs0 rgu0 srcbus 2p
Ccs0 rgu0 0 5p
Cpp0 srcbus ru0 2p
Cppx0 rgu0 tia 2p
Ru1 sum ru1 5000
Cocf1 ru1 tia 2p
Ccf1 ru1 0 5p
Rgu1 hi rgu1 5000
Cocs1 rgu1 srcbus 2p
Ccs1 rgu1 0 5p
Cpp1 srcbus ru1 2p
Cppx1 rgu1 tia 2p
Ccsel_t tia 0 5p
Ccsel_s srcbus 0 5p
Cppsel srcbus tia 2p
R105 hi hpot 1k
R106 low lpot 1k
R107 refa low 1k
Cc4h hi 0 5p
Cc4r refa 0 5p
Coc4 hi refa 2p
Lwhc0 hi hc_n0 0.000000012625000000000002
Cwhc0 hc_n0 0 0.0000000000050500000000000005
Lwhc1 hc_n0 hc_n1 0.000000012625000000000002
Cwhc1 hc_n1 0 0.0000000000050500000000000005
Lwhc2 hc_n1 hc_n2 0.000000012625000000000002
Cwhc2 hc_n2 0 0.0000000000050500000000000005
Lwhc3 hc_n2 hc_n3 0.000000012625000000000002
Cwhc3 hc_n3 0 0.0000000000050500000000000005
Lwhc4 hc_n3 hc_n4 0.000000012625000000000002
Cwhc4 hc_n4 0 0.0000000000050500000000000005
Lwhc5 hc_n4 hc_n5 0.000000012625000000000002
Cwhc5 hc_n5 0 0.0000000000050500000000000005
Lwhc6 hc_n5 hc_n6 0.000000012625000000000002
Cwhc6 hc_n6 0 0.0000000000050500000000000005
Lwhc7 hc_n6 hc_n7 0.000000012625000000000002
Cwhc7 hc_n7 0 0.0000000000050500000000000005
Lwhc8 hc_n7 hc_n8 0.000000012625000000000002
Cwhc8 hc_n8 0 0.0000000000050500000000000005
Lwhc9 hc_n8 hc_n9 0.000000012625000000000002
Cwhc9 hc_n9 0 0.0000000000050500000000000005
Lwhc10 hc_n9 hc_n10 0.000000012625000000000002
Cwhc10 hc_n10 0 0.0000000000050500000000000005
Lwhc11 hc_n10 hc_n11 0.000000012625000000000002
Cwhc11 hc_n11 0 0.0000000000050500000000000005
Lwhc12 hc_n11 hc_n12 0.000000012625000000000002
Cwhc12 hc_n12 0 0.0000000000050500000000000005
Lwhc13 hc_n12 hc_n13 0.000000012625000000000002
Cwhc13 hc_n13 0 0.0000000000050500000000000005
Lwhc14 hc_n13 hc_n14 0.000000012625000000000002
Cwhc14 hc_n14 0 0.0000000000050500000000000005
Lwhc15 hc_n14 hc_n15 0.000000012625000000000002
Cwhc15 hc_n15 0 0.0000000000050500000000000005
Lwhc16 hc_n15 hc_n16 0.000000012625000000000002
Cwhc16 hc_n16 0 0.0000000000050500000000000005
Lwhc17 hc_n16 hc_n17 0.000000012625000000000002
Cwhc17 hc_n17 0 0.0000000000050500000000000005
Lwhc18 hc_n17 hc_n18 0.000000012625000000000002
Cwhc18 hc_n18 0 0.0000000000050500000000000005
Lwhc19 hc_n18 h_dut 0.000000012625000000000002
Cwhc19 h_dut 0 0.0000000000050500000000000005
Lwhp0 hpot hp_n0 0.000000012625000000000002
Cwhp0 hp_n0 0 0.0000000000050500000000000005
Lwhp1 hp_n0 hp_n1 0.000000012625000000000002
Cwhp1 hp_n1 0 0.0000000000050500000000000005
Lwhp2 hp_n1 hp_n2 0.000000012625000000000002
Cwhp2 hp_n2 0 0.0000000000050500000000000005
Lwhp3 hp_n2 hp_n3 0.000000012625000000000002
Cwhp3 hp_n3 0 0.0000000000050500000000000005
Lwhp4 hp_n3 hp_n4 0.000000012625000000000002
Cwhp4 hp_n4 0 0.0000000000050500000000000005
Lwhp5 hp_n4 hp_n5 0.000000012625000000000002
Cwhp5 hp_n5 0 0.0000000000050500000000000005
Lwhp6 hp_n5 hp_n6 0.000000012625000000000002
Cwhp6 hp_n6 0 0.0000000000050500000000000005
Lwhp7 hp_n6 hp_n7 0.000000012625000000000002
Cwhp7 hp_n7 0 0.0000000000050500000000000005
Lwhp8 hp_n7 hp_n8 0.000000012625000000000002
Cwhp8 hp_n8 0 0.0000000000050500000000000005
Lwhp9 hp_n8 hp_n9 0.000000012625000000000002
Cwhp9 hp_n9 0 0.0000000000050500000000000005
Lwhp10 hp_n9 hp_n10 0.000000012625000000000002
Cwhp10 hp_n10 0 0.0000000000050500000000000005
Lwhp11 hp_n10 hp_n11 0.000000012625000000000002
Cwhp11 hp_n11 0 0.0000000000050500000000000005
Lwhp12 hp_n11 hp_n12 0.000000012625000000000002
Cwhp12 hp_n12 0 0.0000000000050500000000000005
Lwhp13 hp_n12 hp_n13 0.000000012625000000000002
Cwhp13 hp_n13 0 0.0000000000050500000000000005
Lwhp14 hp_n13 hp_n14 0.000000012625000000000002
Cwhp14 hp_n14 0 0.0000000000050500000000000005
Lwhp15 hp_n14 hp_n15 0.000000012625000000000002
Cwhp15 hp_n15 0 0.0000000000050500000000000005
Lwhp16 hp_n15 hp_n16 0.000000012625000000000002
Cwhp16 hp_n16 0 0.0000000000050500000000000005
Lwhp17 hp_n16 hp_n17 0.000000012625000000000002
Cwhp17 hp_n17 0 0.0000000000050500000000000005
Lwhp18 hp_n17 hp_n18 0.000000012625000000000002
Cwhp18 hp_n18 0 0.0000000000050500000000000005
Lwhp19 hp_n18 h_dut 0.000000012625000000000002
Cwhp19 h_dut 0 0.0000000000050500000000000005
Lwlc0 low lc_n0 0.000000012625000000000002
Cwlc0 lc_n0 0 0.0000000000050500000000000005
Lwlc1 lc_n0 lc_n1 0.000000012625000000000002
Cwlc1 lc_n1 0 0.0000000000050500000000000005
Lwlc2 lc_n1 lc_n2 0.000000012625000000000002
Cwlc2 lc_n2 0 0.0000000000050500000000000005
Lwlc3 lc_n2 lc_n3 0.000000012625000000000002
Cwlc3 lc_n3 0 0.0000000000050500000000000005
Lwlc4 lc_n3 lc_n4 0.000000012625000000000002
Cwlc4 lc_n4 0 0.0000000000050500000000000005
Lwlc5 lc_n4 lc_n5 0.000000012625000000000002
Cwlc5 lc_n5 0 0.0000000000050500000000000005
Lwlc6 lc_n5 lc_n6 0.000000012625000000000002
Cwlc6 lc_n6 0 0.0000000000050500000000000005
Lwlc7 lc_n6 lc_n7 0.000000012625000000000002
Cwlc7 lc_n7 0 0.0000000000050500000000000005
Lwlc8 lc_n7 lc_n8 0.000000012625000000000002
Cwlc8 lc_n8 0 0.0000000000050500000000000005
Lwlc9 lc_n8 lc_n9 0.000000012625000000000002
Cwlc9 lc_n9 0 0.0000000000050500000000000005
Lwlc10 lc_n9 lc_n10 0.000000012625000000000002
Cwlc10 lc_n10 0 0.0000000000050500000000000005
Lwlc11 lc_n10 lc_n11 0.000000012625000000000002
Cwlc11 lc_n11 0 0.0000000000050500000000000005
Lwlc12 lc_n11 lc_n12 0.000000012625000000000002
Cwlc12 lc_n12 0 0.0000000000050500000000000005
Lwlc13 lc_n12 lc_n13 0.000000012625000000000002
Cwlc13 lc_n13 0 0.0000000000050500000000000005
Lwlc14 lc_n13 lc_n14 0.000000012625000000000002
Cwlc14 lc_n14 0 0.0000000000050500000000000005
Lwlc15 lc_n14 lc_n15 0.000000012625000000000002
Cwlc15 lc_n15 0 0.0000000000050500000000000005
Lwlc16 lc_n15 lc_n16 0.000000012625000000000002
Cwlc16 lc_n16 0 0.0000000000050500000000000005
Lwlc17 lc_n16 lc_n17 0.000000012625000000000002
Cwlc17 lc_n17 0 0.0000000000050500000000000005
Lwlc18 lc_n17 lc_n18 0.000000012625000000000002
Cwlc18 lc_n18 0 0.0000000000050500000000000005
Lwlc19 lc_n18 l_dut 0.000000012625000000000002
Cwlc19 l_dut 0 0.0000000000050500000000000005
Lwlp0 lpot lp_n0 0.000000012625000000000002
Cwlp0 lp_n0 0 0.0000000000050500000000000005
Lwlp1 lp_n0 lp_n1 0.000000012625000000000002
Cwlp1 lp_n1 0 0.0000000000050500000000000005
Lwlp2 lp_n1 lp_n2 0.000000012625000000000002
Cwlp2 lp_n2 0 0.0000000000050500000000000005
Lwlp3 lp_n2 lp_n3 0.000000012625000000000002
Cwlp3 lp_n3 0 0.0000000000050500000000000005
Lwlp4 lp_n3 lp_n4 0.000000012625000000000002
Cwlp4 lp_n4 0 0.0000000000050500000000000005
Lwlp5 lp_n4 lp_n5 0.000000012625000000000002
Cwlp5 lp_n5 0 0.0000000000050500000000000005
Lwlp6 lp_n5 lp_n6 0.000000012625000000000002
Cwlp6 lp_n6 0 0.0000000000050500000000000005
Lwlp7 lp_n6 lp_n7 0.000000012625000000000002
Cwlp7 lp_n7 0 0.0000000000050500000000000005
Lwlp8 lp_n7 lp_n8 0.000000012625000000000002
Cwlp8 lp_n8 0 0.0000000000050500000000000005
Lwlp9 lp_n8 lp_n9 0.000000012625000000000002
Cwlp9 lp_n9 0 0.0000000000050500000000000005
Lwlp10 lp_n9 lp_n10 0.000000012625000000000002
Cwlp10 lp_n10 0 0.0000000000050500000000000005
Lwlp11 lp_n10 lp_n11 0.000000012625000000000002
Cwlp11 lp_n11 0 0.0000000000050500000000000005
Lwlp12 lp_n11 lp_n12 0.000000012625000000000002
Cwlp12 lp_n12 0 0.0000000000050500000000000005
Lwlp13 lp_n12 lp_n13 0.000000012625000000000002
Cwlp13 lp_n13 0 0.0000000000050500000000000005
Lwlp14 lp_n13 lp_n14 0.000000012625000000000002
Cwlp14 lp_n14 0 0.0000000000050500000000000005
Lwlp15 lp_n14 lp_n15 0.000000012625000000000002
Cwlp15 lp_n15 0 0.0000000000050500000000000005
Lwlp16 lp_n15 lp_n16 0.000000012625000000000002
Cwlp16 lp_n16 0 0.0000000000050500000000000005
Lwlp17 lp_n16 lp_n17 0.000000012625000000000002
Cwlp17 lp_n17 0 0.0000000000050500000000000005
Lwlp18 lp_n17 lp_n18 0.000000012625000000000002
Cwlp18 lp_n18 0 0.0000000000050500000000000005
Lwlp19 lp_n18 l_dut 0.000000012625000000000002
Cwlp19 l_dut 0 0.0000000000050500000000000005
RDUT h_dut l_dut 0.01
RF sum rf_end 100000.075
CF sum rf_end 0.000000000000000000000001
X6B hpot highbuf highbuf vp vn OPA2810
X7B lpot lowbuf probe_f vp vn OPA2810
X7A 0 sum tia vp vn OPA2810
Vvcm vcm 0 1.375
Ra1s highbuf a1 1k
Ra1g a1 0 1k
Ca1aa a1 0 560p
Ca1c a1 a1c 1u
Ca1cl a1c 0 10p
Ra1p a1c a1pin 470
Ra1in a1pin vcm 40k
Ca1pin a1pin 0 10p
Ra2s lowbuf a2 1k
Ra2g a2 0 1k
Ca2aa a2 0 560p
Ca2c a2 a2c 1u
Ca2cl a2c 0 10p
Ra2p a2c a2pin 470
Ra2in a2pin vcm 40k
Ca2pin a2pin 0 10p
Rb1s tia b1 1k
Rb1g b1 0 1k
Cb1aa b1 0 560p
Cb1c b1 b1c 1u
Cb1cl b1c 0 10p
Rb1p b1c b1pin 470
Rb1in b1pin vcm 40k
Cb1pin b1pin 0 10p
Rb2s lowbuf b2 1k
Rb2g b2 0 1k
Cb2aa b2 0 560p
Cb2c b2 b2c 1u
Cb2cl b2c 0 10p
Rb2p b2c b2pin 470
Rb2in b2pin vcm 40k
Cb2pin b2pin 0 10p
Rsrciso source srcbus 47
Risolo low sum 22
Cstraylo low 0 0.000000000000000000000001
Cstrayhi hi 0 0.000000000000000000000001
Rbridge lowbuf probe_f 0.01
Iinj 0 lowbuf DC 0 AC 1
Iinj2 0 probe_f DC 0 AC 0
Clocal sum local_cf_out 0.0000000001
Llocal local_cf_out tia 0.00000001
Lfeedback rf_end tia 0.00000007389000000000001
.control
set klu
optran 1 0 0 0 0 0
set wr_singlescale
set wr_vecnames
set numdgt=17
op
wrdata final_revfrelay_r100k_short_coax1m_stray0_risolo22_bhigh_str_k4open_cng100_srciso47_kelvin_caplead10_local100_lead73.89_low_dc.dat v(x5.mid) v(x6a.mid) v(x6b.mid) v(x7a.mid) v(x7b.mid) v(excite) v(source) v(hi) v(low) v(tia) v(highbuf) v(lowbuf)
ac dec 120 1 1G
let ve=v(lowbuf)
let vf=v(probe_f)
wrdata final_revfrelay_r100k_short_coax1m_stray0_risolo22_bhigh_str_k4open_cng100_srciso47_kelvin_caplead10_local100_lead73.89_low_e.dat real(ve) imag(ve) real(vf) imag(vf)
alter Iinj ac=0
alter Iinj2 ac=1
ac dec 120 1 1G
let ve=v(lowbuf)
let vf=v(probe_f)
wrdata final_revfrelay_r100k_short_coax1m_stray0_risolo22_bhigh_str_k4open_cng100_srciso47_kelvin_caplead10_local100_lead73.89_low_f.dat real(ve) imag(ve) real(vf) imag(vf)
quit
.endc
.end
