RevC final exact full chain; official models; real FDA bias and ADC RC loads
.include ../../sources/ti/models/opa2810_a.lib
.include ../../sources/ti/models/opa810_a.lib
.include ../../sources/ti/models/ths4551.lib
.options reltol=1e-5 abstol=1e-12 vntol=1e-7 method=gear
.include ../solver-resolution-rev-c-final/final-seed.inc
.nodeset v(probe_f)=0.000100193
Cbflt2 badc_m 0 330p
Rbi1 lowbuf bip 1k
Rai2 lowbuf aim 1k
X7B low lowbuf lowbuf vp vn OPA2810
Cbadc2 badc_m 0 16p
Cbflt1 badc_p 0 330p
RF low tia 4995
X6A excite source source vp vn OPA2810
Rbi2 tia bim 1k
Caflt1 aadc_p 0 330p
Raiso1 afbp aadc_p 4.32
R30 dds lp1 330
C34 lp1 0 1n
Rbint1 bom bfbm 22
X5 acin srcfb excite vp vn OPA810
X6B hi highbuf highbuf vp vn OPA2810
Caflt2 aadc_m 0 330p
Iinj 0 low DC 0 AC 1
Cfbb2 bfbp bim 100p
Rbint2 bop bfbp 22
Cbadc1 badc_p 0 16p
C36 lp2 acin 1u
Cfbb1 bfbm bip 100p
Raiso2 afbm aadc_m 4.32
R34 srcfb 0 1k
Cstrayhi hi 0 0.000000000000000000000001
Rbiso1 bfbp badc_p 4.32
Rbf1 bfbm bip 1k
Vn vn 0 -12.600000000000001
Rbiso2 bfbm badc_m 4.32
Rbf2 bfbp bim 1k
Xb bip bim bop bom cm v5 0 THS4551
Iinj2 0 probe_f DC 0 AC 0
V5 v5 0 5.25
C35 lp2 0 1n
Caadc1 aadc_p 0 16p
R32 acin 0 100k
CF low tia 0.0000000000105
Cfba1 afbm aip 100p
Cbdiff badc_p badc_m 3.3n
Raf1 afbm aip 1k
Raf2 afbp aim 1k
Raint2 aop afbp 22
Rai1 highbuf aip 1k
RG source hi 5004.999999999999
Cstraylo low 0 0.000000000000000000000001
X7A 0 probe_f tia vp vn OPA2810
Rbridge low probe_f 100
RDUT hi low 1e12
Cadiff aadc_p aadc_m 3.3n
Vdds dds0 0 DC 0.3 AC 0
Rdds dds0 dds 200
Vcm cm 0 2.048
Xa aip aim aop aom cm v5 0 THS4551
Raint1 aom afbm 22
R33 excite srcfb 5k
Vp vp 0 12.600000000000001
Cfba2 afbp aim 100p
R31 lp1 lp2 330
Caadc2 aadc_m 0 16p
.control
set klu
optran 1 0 0 0 0 0
set filetype=ascii
set numdgt=17
op
write final_rev_c_r5k_open_stray0_corner1_tia-order18.raw all
quit
.endc
.end
