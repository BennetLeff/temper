RevC final exact full chain; official models; real FDA bias and ADC RC loads
.include ../../sources/ti/models/opa2810_a.lib
.include ../../sources/ti/models/opa810_a.lib
.include ../../sources/ti/models/ths4551.lib
.options reltol=1e-5 abstol=1e-12 vntol=1e-7 method=gear
.include ../solver-resolution-rev-c-final/final-seed.inc
.nodeset v(probe_f)=0.000100193
Vp vp 0 12.600000000000001
R33 excite srcfb 5k
Cfbb1 bfbm bip 100p
R32 acin 0 100k
Cstraylo low 0 0.000000000000000000000001
Caflt1 aadc_p 0 330p
Cbflt2 badc_m 0 330p
Cbadc2 badc_m 0 16p
Rbi1 lowbuf bip 1k
Rbiso1 bfbp badc_p 4.32
C35 lp2 0 1n
Cfba1 afbm aip 100p
Caflt2 aadc_m 0 330p
X6A excite source source vp vn OPA2810
Vdds dds0 0 DC 0.3 AC 0
Caadc1 aadc_p 0 16p
X7A 0 probe_f tia vp vn OPA2810
X7B low lowbuf lowbuf vp vn OPA2810
Raint1 aom afbm 22
X5 acin srcfb excite vp vn OPA810
Caadc2 aadc_m 0 16p
Cbadc1 badc_p 0 16p
Raf2 afbp aim 1k
R34 srcfb 0 1k
X6B hi highbuf highbuf vp vn OPA2810
Rbint1 bom bfbm 22
Rbf1 bfbm bip 1k
Cbflt1 badc_p 0 330p
Xb bip bim bop bom cm v5 0 THS4551
Iinj 0 low DC 0 AC 1
Rai2 lowbuf aim 1k
Cfba2 afbp aim 100p
R31 lp1 lp2 330
RF low tia 99900
Cfbb2 bfbp bim 100p
CF low tia 0.00000000000525
Raf1 afbm aip 1k
Raiso2 afbm aadc_m 4.32
Rbi2 tia bim 1k
R30 dds lp1 330
RG source hi 100099.99999999999
Raint2 aop afbp 22
Rbint2 bop bfbp 22
Cstrayhi hi 0 0.000000000000000000000001
Rbridge low probe_f 100
Rbiso2 bfbm badc_m 4.32
Cbdiff badc_p badc_m 3.3n
V5 v5 0 5.25
C34 lp1 0 1n
Rbf2 bfbp bim 1k
Vn vn 0 -12.600000000000001
C36 lp2 acin 1u
Xa aip aim aop aom cm v5 0 THS4551
Vcm cm 0 2.048
Rdds dds0 dds 200
Iinj2 0 probe_f DC 0 AC 0
Raiso1 afbp aadc_p 4.32
Cadiff aadc_p aadc_m 3.3n
Rai1 highbuf aip 1k
RDUT hi low 100000
.control
set klu
optran 1 0 0 0 0 0
set filetype=ascii
set numdgt=17
op
write final_rev_c_r100k_matched_stray0_corner1_tia-order12.raw all
quit
.endc
.end
