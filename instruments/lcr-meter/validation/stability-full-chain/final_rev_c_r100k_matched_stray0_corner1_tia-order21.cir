RevC final exact full chain; official models; real FDA bias and ADC RC loads
.include ../../sources/ti/models/opa2810_a.lib
.include ../../sources/ti/models/opa810_a.lib
.include ../../sources/ti/models/ths4551.lib
.options reltol=1e-5 abstol=1e-12 vntol=1e-7 method=gear
.include ../solver-resolution-rev-c-final/final-seed.inc
.nodeset v(probe_f)=0.000100193
Cadiff aadc_p aadc_m 3.3n
X6A excite source source vp vn OPA2810
Caadc1 aadc_p 0 16p
R33 excite srcfb 5k
Cbdiff badc_p badc_m 3.3n
Rbiso1 bfbp badc_p 4.32
Iinj 0 low DC 0 AC 1
X5 acin srcfb excite vp vn OPA810
X7B low lowbuf lowbuf vp vn OPA2810
C36 lp2 acin 1u
Raf1 afbm aip 1k
Rbint1 bom bfbm 22
Rbint2 bop bfbp 22
Raf2 afbp aim 1k
Cfba1 afbm aip 100p
RF low tia 99900
Rbridge low probe_f 100
Cstrayhi hi 0 0.000000000000000000000001
Raint1 aom afbm 22
R31 lp1 lp2 330
Cfbb2 bfbp bim 100p
Iinj2 0 probe_f DC 0 AC 0
Cbflt1 badc_p 0 330p
Xa aip aim aop aom cm v5 0 THS4551
Caflt2 aadc_m 0 330p
C34 lp1 0 1n
Cfbb1 bfbm bip 100p
X7A 0 probe_f tia vp vn OPA2810
Caadc2 aadc_m 0 16p
RG source hi 100099.99999999999
Cfba2 afbp aim 100p
Rai1 highbuf aip 1k
Cbadc1 badc_p 0 16p
Vdds dds0 0 DC 0.3 AC 0
Caflt1 aadc_p 0 330p
Rbiso2 bfbm badc_m 4.32
Vp vp 0 12.600000000000001
Raint2 aop afbp 22
RDUT hi low 100000
Rdds dds0 dds 200
Rbi2 tia bim 1k
Rbf2 bfbp bim 1k
Rbi1 lowbuf bip 1k
R34 srcfb 0 1k
Rai2 lowbuf aim 1k
Cbadc2 badc_m 0 16p
Rbf1 bfbm bip 1k
Raiso1 afbp aadc_p 4.32
Xb bip bim bop bom cm v5 0 THS4551
CF low tia 0.00000000000525
Cbflt2 badc_m 0 330p
Cstraylo low 0 0.000000000000000000000001
Vn vn 0 -12.600000000000001
C35 lp2 0 1n
R30 dds lp1 330
X6B hi highbuf highbuf vp vn OPA2810
Vcm cm 0 2.048
V5 v5 0 5.25
Raiso2 afbm aadc_m 4.32
R32 acin 0 100k
.control
set klu
optran 1 0 0 0 0 0
set filetype=ascii
set numdgt=17
op
write final_rev_c_r100k_matched_stray0_corner1_tia-order21.raw all
quit
.endc
.end
