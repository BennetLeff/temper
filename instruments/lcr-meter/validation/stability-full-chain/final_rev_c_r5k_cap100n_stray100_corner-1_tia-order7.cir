RevC final exact full chain; official models; real FDA bias and ADC RC loads
.include ../../sources/ti/models/opa2810_a.lib
.include ../../sources/ti/models/opa810_a.lib
.include ../../sources/ti/models/ths4551.lib
.options reltol=1e-5 abstol=1e-12 vntol=1e-7 method=gear
.include ../solver-resolution-rev-c-final/final-seed.inc
.nodeset v(probe_f)=0.000100193
Cfba2 afbp aim 100p
Raint2 aop afbp 22
Rai1 highbuf aip 1k
Cbdiff badc_p badc_m 3.3n
V5 v5 0 4.75
Rbridge low probe_f 100
X6B hi highbuf highbuf vp vn OPA2810
Cbadc1 badc_p 0 16p
Rbint2 bop bfbp 22
Xa aip aim aop aom cm v5 0 THS4551
Rbf1 bfbm bip 1k
Iinj2 0 probe_f DC 0 AC 0
Cfba1 afbm aip 100p
Cstraylo low 0 0.0000000001
Iinj 0 low DC 0 AC 1
Caadc2 aadc_m 0 16p
Raiso1 afbp aadc_p 4.32
Caadc1 aadc_p 0 16p
Cbadc2 badc_m 0 16p
Raf2 afbp aim 1k
Rbiso1 bfbp badc_p 4.32
CF low tia 0.0000000000095
C36 lp2 acin 1u
Caflt1 aadc_p 0 330p
CDUT hi low 100n
Raiso2 afbm aadc_m 4.32
R32 acin 0 100k
Rdds dds0 dds 200
R30 dds lp1 330
Xb bip bim bop bom cm v5 0 THS4551
Caflt2 aadc_m 0 330p
Raint1 aom afbm 22
Cbflt1 badc_p 0 330p
Cadiff aadc_p aadc_m 3.3n
Rbi1 lowbuf bip 1k
X5 acin srcfb excite vp vn OPA810
Rbf2 bfbp bim 1k
Vn vn 0 -11.399999999999999
R34 srcfb 0 1k
R33 excite srcfb 5k
C34 lp1 0 1n
RG source hi 4995
R31 lp1 lp2 330
Vdds dds0 0 DC 0.3 AC 0
Cfbb1 bfbm bip 100p
C35 lp2 0 1n
Vp vp 0 11.399999999999999
Cfbb2 bfbp bim 100p
X7A 0 probe_f tia vp vn OPA2810
Rbint1 bom bfbm 22
X7B low lowbuf lowbuf vp vn OPA2810
Rbi2 tia bim 1k
Cbflt2 badc_m 0 330p
RF low tia 5004.999999999999
Vcm cm 0 2.048
Rai2 lowbuf aim 1k
Rbiso2 bfbm badc_m 4.32
X6A excite source source vp vn OPA2810
Cstrayhi hi 0 0.0000000001
Raf1 afbm aip 1k
.control
set klu
optran 1 0 0 0 0 0
set filetype=ascii
set numdgt=17
op
write final_rev_c_r5k_cap100n_stray100_corner-1_tia-order7.raw all
quit
.endc
.end
