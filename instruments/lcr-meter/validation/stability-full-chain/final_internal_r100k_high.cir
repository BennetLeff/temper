RevC final exact full chain; official models; real FDA bias and ADC RC loads
.include ../../sources/ti/models/opa2810_a.lib
.include ../../sources/ti/models/opa810_a.lib
.include ../../sources/ti/models/ths4551.lib
.options reltol=1e-5 abstol=1e-12 vntol=1e-7 method=gear
.include ../solver-resolution-rev-c-final/final-seed.inc
.include OPA2810-internal-probe.lib
Cbflt2 badc_m 0 330p
Rai2 lowbuf aim 1k
Caflt2 aadc_m 0 330p
Rbiso2 bfbm badc_m 4.32
RG source hi 100000
Caadc2 aadc_m 0 16p
X5 acin srcfb excite vp vn OPA810
Rbi2 tia bim 1k
Cfba1 afbm aip 100p
R30 dds lp1 330
R31 lp1 lp2 330
Rbiso1 bfbp badc_p 4.32
Raiso2 afbm aadc_m 4.32
RF low tia 100000
Rbint1 bom bfbm 22
X6B hi highbuf highbuf vp vn OPA2810_PROBE
Xa aip aim aop aom cm v5 0 THS4551
Rdds dds0 dds 200
Raint1 aom afbm 22
Xb bip bim bop bom cm v5 0 THS4551
Caflt1 aadc_p 0 330p
Cfbb2 bfbp bim 100p
Rbf1 bfbm bip 1k
R34 srcfb 0 1k
Vp vp 0 12
Cbflt1 badc_p 0 330p
RDUT hi low 100000
Rbi1 lowbuf bip 1k
Cadiff aadc_p aadc_m 3.3n
C34 lp1 0 1n
Rai1 highbuf aip 1k
C36 lp2 acin 1u
Vn vn 0 -12
Cbadc1 badc_p 0 16p
Vdds dds0 0 DC 0.3 AC 0
Cfbb1 bfbm bip 100p
Raf2 afbp aim 1k
R33 excite srcfb 5k
Raint2 aop afbp 22
Cbdiff badc_p badc_m 3.3n
X6A excite source source vp vn OPA2810
Cfba2 afbp aim 100p
X7B low lowbuf lowbuf vp vn OPA2810
C35 lp2 0 1n
Rbf2 bfbp bim 1k
Caadc1 aadc_p 0 16p
Vcm cm 0 2.048
CF low tia 0.000000000005
V5 v5 0 5
Rbint2 bop bfbp 22
X7A 0 low tia vp vn OPA2810
Cbadc2 badc_m 0 16p
Raiso1 afbp aadc_p 4.32
R32 acin 0 100k
Raf1 afbm aip 1k
.control
set klu
optran 1 0 0 0 0 0
set wr_singlescale
set wr_vecnames
set numdgt=17
op
wrdata final_internal_r100k_high_dc.dat v(x5.mid) v(x6a.mid) v(x6b.mid) v(x7a.mid) v(x7b.mid) v(xa.mid) v(xb.mid) v(acin)
ac dec 240 1 1G
let t=-v(x6b.n31014,x6b.n11991)/v(x6b.nprobe,x6b.n11991)
wrdata final_internal_r100k_high_return.dat real(t) imag(t)
quit
.endc
.end
