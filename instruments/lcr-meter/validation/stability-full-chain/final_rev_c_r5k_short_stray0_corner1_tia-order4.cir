RevC final exact full chain; official models; real FDA bias and ADC RC loads
.include ../../sources/ti/models/opa2810_a.lib
.include ../../sources/ti/models/opa810_a.lib
.include ../../sources/ti/models/ths4551.lib
.options reltol=1e-5 abstol=1e-12 vntol=1e-7 method=gear
.include ../solver-resolution-rev-c-final/final-seed.inc
.nodeset v(probe_f)=0.000100193
Rbiso1 bfbp badc_p 4.32
Cfbb1 bfbm bip 100p
Raint1 aom afbm 22
Rbridge low probe_f 100
Rbint1 bom bfbm 22
X7B low lowbuf lowbuf vp vn OPA2810
R32 acin 0 100k
Rbf1 bfbm bip 1k
V5 v5 0 5.25
C35 lp2 0 1n
Rbiso2 bfbm badc_m 4.32
Rai2 lowbuf aim 1k
Rai1 highbuf aip 1k
RDUT hi low 0.01
Cbadc2 badc_m 0 16p
RG source hi 5004.999999999999
Cadiff aadc_p aadc_m 3.3n
Rbf2 bfbp bim 1k
Raf2 afbp aim 1k
Caadc2 aadc_m 0 16p
Vcm cm 0 2.048
R31 lp1 lp2 330
Raiso1 afbp aadc_p 4.32
Xb bip bim bop bom cm v5 0 THS4551
Xa aip aim aop aom cm v5 0 THS4551
Caflt1 aadc_p 0 330p
Cfbb2 bfbp bim 100p
X6B hi highbuf highbuf vp vn OPA2810
Vp vp 0 12.600000000000001
Cstraylo low 0 0.000000000000000000000001
Cbdiff badc_p badc_m 3.3n
Iinj 0 low DC 0 AC 1
Raiso2 afbm aadc_m 4.32
R34 srcfb 0 1k
RF low tia 4995
Rbint2 bop bfbp 22
C34 lp1 0 1n
CF low tia 0.0000000000105
X6A excite source source vp vn OPA2810
X5 acin srcfb excite vp vn OPA810
C36 lp2 acin 1u
Cbflt1 badc_p 0 330p
R33 excite srcfb 5k
Vdds dds0 0 DC 0.3 AC 0
Raint2 aop afbp 22
Cbflt2 badc_m 0 330p
R30 dds lp1 330
X7A 0 probe_f tia vp vn OPA2810
Cbadc1 badc_p 0 16p
Iinj2 0 probe_f DC 0 AC 0
Caflt2 aadc_m 0 330p
Rdds dds0 dds 200
Caadc1 aadc_p 0 16p
Cstrayhi hi 0 0.000000000000000000000001
Raf1 afbm aip 1k
Rbi2 tia bim 1k
Cfba1 afbm aip 100p
Vn vn 0 -12.600000000000001
Rbi1 lowbuf bip 1k
Cfba2 afbp aim 100p
.control
set klu
optran 1 0 0 0 0 0
set filetype=ascii
set numdgt=17
op
write final_rev_c_r5k_short_stray0_corner1_tia-order4.raw all
quit
.endc
.end
