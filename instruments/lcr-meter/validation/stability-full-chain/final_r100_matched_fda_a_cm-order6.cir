RevC final exact full chain; official models; real FDA bias and ADC RC loads
.include ../../sources/ti/models/opa2810_a.lib
.include ../../sources/ti/models/opa810_a.lib
.include ../../sources/ti/models/ths4551.lib
.options reltol=1e-5 abstol=1e-12 vntol=1e-7 method=gear
.include ../solver-resolution-rev-c-final/final-seed.inc
.nodeset v(probe_fp)=1.0228 v(probe_fm)=1.0228
Raf1 afbm aip 1k
Cbflt2 badc_m 0 330p
X5 acin srcfb excite vp vn OPA810
Cfbb1 bfbm bip 100p
Rbint2 bop bfbp 22
R34 srcfb 0 1k
Cbadc1 badc_p 0 16p
Rbf2 bfbp bim 1k
X7B low lowbuf lowbuf vp vn OPA2810
C36 lp2 acin 1u
Caadc1 aadc_p 0 16p
Iinj2m 0 probe_fm DC 0 AC 0
RF low tia 100
Rdds dds0 dds 200
Rbridgem aim probe_fm 10
Cfbb2 bfbp bim 100p
X7A 0 low tia vp vn OPA2810
CF low tia 0.0000000001
Cadiff aadc_p aadc_m 3.3n
Caflt2 aadc_m 0 330p
Rbiso2 bfbm badc_m 4.32
Xb bip bim bop bom cm v5 0 THS4551
RG source hi 100
Raf2 afbp aim 1k
Cbdiff badc_p badc_m 3.3n
R33 excite srcfb 5k
R32 acin 0 100k
Cstraylo low 0 0.000000000000000000000001
Rai1 highbuf aip 1k
Rbridgep aip probe_fp 10
Cfba1 afbm aip 100p
Raint1 aom afbm 22
Cfba2 afbp aim 100p
Raiso2 afbm aadc_m 4.32
V5 v5 0 5
Raiso1 afbp aadc_p 4.32
Xa probe_fp probe_fm aop aom cm v5 0 THS4551
Vp vp 0 12
R31 lp1 lp2 330
Rbiso1 bfbp badc_p 4.32
Cbadc2 badc_m 0 16p
Rbi1 lowbuf bip 1k
Vdds dds0 0 DC 0.3 AC 0
Rai2 lowbuf aim 1k
Raint2 aop afbp 22
Rbf1 bfbm bip 1k
C35 lp2 0 1n
R30 dds lp1 330
Caflt1 aadc_p 0 330p
Cstrayhi hi 0 0.000000000000000000000001
X6B hi highbuf highbuf vp vn OPA2810
Vn vn 0 -12
Rbint1 bom bfbm 22
Vcm cm 0 2.048
Rbi2 tia bim 1k
RDUT hi low 100
Iinjm 0 aim DC 0 AC 0.5
Iinj 0 aip DC 0 AC 0.5
C34 lp1 0 1n
Iinj2 0 probe_fp DC 0 AC 0
Caadc2 aadc_m 0 16p
X6A excite source source vp vn OPA2810
Cbflt1 badc_p 0 330p
.control
set klu
optran 1 0 0 0 0 0
set filetype=ascii
set numdgt=17
op
write final_r100_matched_fda_a_cm-order6.raw all
quit
.endc
.end
