RevC final exact full chain; official models; real FDA bias and ADC RC loads
.include ../../sources/ti/models/opa2810_a.lib
.include ../../sources/ti/models/opa810_a.lib
.include ../../sources/ti/models/ths4551.lib
.options reltol=1e-5 abstol=1e-12 vntol=1e-7 method=gear
.include ../solver-resolution-rev-c-final/final-seed.inc
.include OPA2810-internal-probe.lib
C34 lp1 0 1n
Rbf1 bfbm bip 1k
Vp vp 0 12
Cbadc1 badc_p 0 16p
Rbi2 tia bim 1k
Vn vn 0 -12
Rdds dds0 dds 200
Cbflt1 badc_p 0 330p
R32 acin 0 100k
RF low tia 100000
Cfbb1 bfbm bip 100p
RDUT hi low 100000
Xa aip aim aop aom cm v5 0 THS4551
Cfba1 afbm aip 100p
Rai1 highbuf aip 1k
Caflt2 aadc_m 0 330p
Vdds dds0 0 DC 0.3 AC 0
Raf2 afbp aim 1k
Raiso1 afbp aadc_p 4.32
Cbadc2 badc_m 0 16p
Raiso2 afbm aadc_m 4.32
Rbint1 bom bfbm 22
RG source hi 100000
C35 lp2 0 1n
Caadc1 aadc_p 0 16p
Cbflt2 badc_m 0 330p
Raf1 afbm aip 1k
Vcm cm 0 2.048
C36 lp2 acin 1u
Rai2 lowbuf aim 1k
X5 acin srcfb excite vp vn OPA810
X7B low lowbuf lowbuf vp vn OPA2810
R30 dds lp1 330
X6A excite source source vp vn OPA2810
X6B hi highbuf highbuf vp vn OPA2810_PROBE
Raint1 aom afbm 22
R34 srcfb 0 1k
Cfba2 afbp aim 100p
Cadiff aadc_p aadc_m 3.3n
V5 v5 0 5
Rbint2 bop bfbp 22
Xb bip bim bop bom cm v5 0 THS4551
Caflt1 aadc_p 0 330p
R31 lp1 lp2 330
Cfbb2 bfbp bim 100p
Cbdiff badc_p badc_m 3.3n
X7A 0 low tia vp vn OPA2810
Rbiso1 bfbp badc_p 4.32
R33 excite srcfb 5k
Raint2 aop afbp 22
Rbiso2 bfbm badc_m 4.32
CF low tia 0.000000000005
Rbf2 bfbp bim 1k
Caadc2 aadc_m 0 16p
Rbi1 lowbuf bip 1k
.control
set klu
optran 1 0 0 0 0 0
set filetype=ascii
set numdgt=17
op
write final_internal_r100k_high-order11.raw all
quit
.endc
.end
