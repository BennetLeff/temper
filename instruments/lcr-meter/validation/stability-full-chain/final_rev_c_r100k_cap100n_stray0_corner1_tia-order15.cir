RevC final exact full chain; official models; real FDA bias and ADC RC loads
.include ../../sources/ti/models/opa2810_a.lib
.include ../../sources/ti/models/opa810_a.lib
.include ../../sources/ti/models/ths4551.lib
.options reltol=1e-5 abstol=1e-12 vntol=1e-7 method=gear
.include ../solver-resolution-rev-c-final/final-seed.inc
.nodeset v(probe_f)=0.000100193
Rbi1 lowbuf bip 1k
Caflt1 aadc_p 0 330p
Rbint2 bop bfbp 22
Rai2 lowbuf aim 1k
Raint2 aop afbp 22
X5 acin srcfb excite vp vn OPA810
Rai1 highbuf aip 1k
X7B low lowbuf lowbuf vp vn OPA2810
Caadc2 aadc_m 0 16p
Raint1 aom afbm 22
Cfbb2 bfbp bim 100p
Rbiso2 bfbm badc_m 4.32
CDUT hi low 100n
Rbf1 bfbm bip 1k
Rbiso1 bfbp badc_p 4.32
X6B hi highbuf highbuf vp vn OPA2810
R31 lp1 lp2 330
V5 v5 0 5.25
Rdds dds0 dds 200
Iinj 0 low DC 0 AC 1
Cfbb1 bfbm bip 100p
Vdds dds0 0 DC 0.3 AC 0
Rbridge low probe_f 100
Vp vp 0 12.600000000000001
Caadc1 aadc_p 0 16p
Rbi2 tia bim 1k
Raf2 afbp aim 1k
Cbflt2 badc_m 0 330p
R30 dds lp1 330
Cadiff aadc_p aadc_m 3.3n
Cbadc1 badc_p 0 16p
Cbdiff badc_p badc_m 3.3n
R33 excite srcfb 5k
Iinj2 0 probe_f DC 0 AC 0
Rbf2 bfbp bim 1k
Vn vn 0 -12.600000000000001
C35 lp2 0 1n
Cbflt1 badc_p 0 330p
CF low tia 0.00000000000525
Cstrayhi hi 0 0.000000000000000000000001
R34 srcfb 0 1k
Caflt2 aadc_m 0 330p
RF low tia 99900
Rbint1 bom bfbm 22
Cstraylo low 0 0.000000000000000000000001
Raiso2 afbm aadc_m 4.32
X6A excite source source vp vn OPA2810
C34 lp1 0 1n
X7A 0 probe_f tia vp vn OPA2810
R32 acin 0 100k
C36 lp2 acin 1u
Cfba1 afbm aip 100p
Xa aip aim aop aom cm v5 0 THS4551
Raf1 afbm aip 1k
RG source hi 100099.99999999999
Xb bip bim bop bom cm v5 0 THS4551
Vcm cm 0 2.048
Cfba2 afbp aim 100p
Cbadc2 badc_m 0 16p
Raiso1 afbp aadc_p 4.32
.control
set klu
optran 1 0 0 0 0 0
set filetype=ascii
set numdgt=17
op
write final_rev_c_r100k_cap100n_stray0_corner1_tia-order15.raw all
quit
.endc
.end
