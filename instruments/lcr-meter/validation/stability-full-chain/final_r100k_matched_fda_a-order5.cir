RevC final exact full chain; official models; real FDA bias and ADC RC loads
.include ../../sources/ti/models/opa2810_a.lib
.include ../../sources/ti/models/opa810_a.lib
.include ../../sources/ti/models/ths4551.lib
.options reltol=1e-5 abstol=1e-12 vntol=1e-7 method=gear
.include ../solver-resolution-rev-c-final/final-seed.inc
.nodeset v(probe_fp)=1.0228 v(probe_fm)=1.0228
X7B low lowbuf lowbuf vp vn OPA2810
Iinj2 0 probe_fp DC 0 AC 0
Cbadc2 badc_m 0 16p
Rbridgep aip probe_fp 10
Cadiff aadc_p aadc_m 3.3n
X6B hi highbuf highbuf vp vn OPA2810
Caflt2 aadc_m 0 330p
R33 excite srcfb 5k
RDUT hi low 100000
C35 lp2 0 1n
Vn vn 0 -12
Raint2 aop afbp 22
Iinjm aim 0 DC 0 AC 1
RF low tia 100000
Raiso1 afbp aadc_p 4.32
Xb bip bim bop bom cm v5 0 THS4551
Xa probe_fp probe_fm aop aom cm v5 0 THS4551
Caflt1 aadc_p 0 330p
Rbi2 tia bim 1k
Rdds dds0 dds 200
Cbdiff badc_p badc_m 3.3n
Rbiso2 bfbm badc_m 4.32
Cfbb1 bfbm bip 100p
Cstraylo low 0 0.000000000000000000000001
RG source hi 100000
Iinj2m probe_fm 0 DC 0 AC 0
Rbint2 bop bfbp 22
Rai1 highbuf aip 1k
Vdds dds0 0 DC 0.3 AC 0
Rbint1 bom bfbm 22
Raint1 aom afbm 22
Rbf2 bfbp bim 1k
Caadc2 aadc_m 0 16p
Cfbb2 bfbp bim 100p
C36 lp2 acin 1u
Caadc1 aadc_p 0 16p
CF low tia 0.000000000005
Cfba1 afbm aip 100p
X7A 0 low tia vp vn OPA2810
Cbflt1 badc_p 0 330p
Iinj 0 aip DC 0 AC 1
R32 acin 0 100k
X6A excite source source vp vn OPA2810
Cbflt2 badc_m 0 330p
X5 acin srcfb excite vp vn OPA810
Cbadc1 badc_p 0 16p
Raiso2 afbm aadc_m 4.32
Rai2 lowbuf aim 1k
V5 v5 0 5
Vcm cm 0 2.048
Cfba2 afbp aim 100p
Vp vp 0 12
R30 dds lp1 330
Rbridgem aim probe_fm 10
Raf2 afbp aim 1k
R31 lp1 lp2 330
R34 srcfb 0 1k
Rbi1 lowbuf bip 1k
Rbf1 bfbm bip 1k
C34 lp1 0 1n
Cstrayhi hi 0 0.000000000000000000000001
Rbiso1 bfbp badc_p 4.32
Raf1 afbm aip 1k
.control
set klu
optran 1 0 0 0 0 0
set filetype=ascii
set numdgt=17
op
write final_r100k_matched_fda_a-order5.raw all
quit
.endc
.end
