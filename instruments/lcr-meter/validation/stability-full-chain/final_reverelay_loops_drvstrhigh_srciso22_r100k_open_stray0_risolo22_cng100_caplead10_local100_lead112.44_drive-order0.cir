RevE codec front end: TAC5112 DAC -> OPA810 difference stage -> TIDA core -> 1k/1k attenuators -> AC coupling -> codec inputs
.include ../../sources/ti/models/opa2810_a.lib
.include ../../sources/ti/models/opa810_a.lib
.options reltol=1e-5 abstol=1e-12 vntol=1e-7 method=gear
.include codec-seed.inc
* TAC5112 line outputs: 1.65 V common mode (datasheet 6.x), 10 ohm output resistance ASSUMED
* Difference stage, gain 2.0k/2.2k, pole 295 kHz; DC coupled (no settle), rejects the 1.65 V common mode
* Codec inputs (AC-coupled differential, 40 kOhm wideband setting, CM_TOL 01): CH1 = highbuf - lowbuf,
* CH2 = tia - lowbuf. Each leg: 1k/1k divider, 560 pF anti-alias, 1 uF coupling, BAT54S clamp (10 pF),
* 470 ohm series, pin = 40 kOhm to the internal common mode plus 10 pF (pin capacitance ASSUMED).
.nodeset v(probe_f)=0.000554524
Vp vp 0 12
Vn vn 0 -12
V5 v5 0 5
Vdacp dacp0 0 DC 1.65 AC 0
Vdacm dacm0 0 DC 1.65 AC 0
Rdacp dacp0 dacp 10
Rdacm dacm0 dacm 10
Rsa dacp acin 2.2k
Rsb acin 0 2.0k
Csb acin 0 270p
Rsc dacm srcfb 2.2k
Rsf excite srcfb 2.0k
Csf excite srcfb 270p
X5 acin srcfb excite vp vn OPA810
X6A excite source probe_f vp vn OPA2810
RG srcbus hi 100000.075
Cng low 0 100p
Cxg_sum sum 0 1.0608p
Cxg_low low 0 6.3345p
Cxg_tia tia 0 14.6239p
Cxg_hi hi 0 10.2339p
Cxg_ru0 ru0 0 3.0517p
Cxg_ru1 ru1 0 3.1810p
Cxg_lowbuf lowbuf 0 3.6023p
Cxg_highbuf highbuf 0 2.0843p
Cxg_source srcbus 0 13.2268p
Cxg_rgu0 rgu0 0 2.2749p
Cxg_rgu1 rgu1 0 2.2747p
Cxm_sum_low sum low 0.1176p
Cxm_sum_tia sum tia 0.3206p
Cxm_sum_ru0 sum ru0 0.1446p
Cxm_sum_ru1 sum ru1 0.1261p
Cxm_sum_lowbuf sum lowbuf 0.0239p
Cxm_low_tia low tia 0.0138p
Cxm_low_hi low hi 0.1624p
Cxm_low_lowbuf low lowbuf 0.1422p
Cxm_low_highbuf low highbuf 0.0015p
Cxm_tia_hi tia hi 0.0048p
Cxm_tia_ru0 tia ru0 0.9199p
Cxm_tia_ru1 tia ru1 0.0229p
Cxm_tia_lowbuf tia lowbuf 0.0100p
Cxm_tia_highbuf tia highbuf 0.1725p
Cxm_tia_source tia srcbus 0.0666p
Cxm_hi_highbuf hi highbuf 0.0749p
Cxm_hi_source hi srcbus 2.9892p
Cxm_hi_rgu0 hi rgu0 0.1010p
Cxm_hi_rgu1 hi rgu1 0.1010p
Cxm_ru0_ru1 ru0 ru1 0.0057p
Cxm_ru0_source ru0 srcbus 0.0045p
Cxm_lowbuf_highbuf lowbuf highbuf 0.0471p
Cxm_highbuf_source highbuf srcbus 0.0054p
Cxm_source_rgu0 srcbus rgu0 0.0022p
Cxm_source_rgu1 srcbus rgu1 0.0024p
Ru0 sum ru0 100
Cocf0 ru0 tia 2p
Ccf0 ru0 0 5p
Rgu0 hi rgu0 100
Cocs0 rgu0 srcbus 2p
Ccs0 rgu0 0 5p
Cpp0 srcbus ru0 2p
Cppx0 rgu0 tia 2p
Ru1 sum ru1 5000
Cocf1 ru1 tia 2p
Ccf1 ru1 0 5p
Rgu1 hi rgu1 5000
Cocs1 rgu1 srcbus 2p
Ccs1 rgu1 0 5p
Cpp1 srcbus ru1 2p
Cppx1 rgu1 tia 2p
Ccsel_t tia 0 5p
Ccsel_s srcbus 0 5p
Cppsel srcbus tia 2p
RDUT hi low 1e12
RF sum rf_end 100000.075
CF sum rf_end 0.000000000000000000000001
X6B hi highbuf highbuf vp vn OPA2810
X7B low lowbuf lowbuf vp vn OPA2810
X7A 0 sum tia vp vn OPA2810
Vvcm vcm 0 1.375
Ra1s highbuf a1 1k
Ra1g a1 0 1k
Ca1aa a1 0 560p
Ca1c a1 a1c 1u
Ca1cl a1c 0 10p
Ra1p a1c a1pin 470
Ra1in a1pin vcm 40k
Ca1pin a1pin 0 10p
Ra2s lowbuf a2 1k
Ra2g a2 0 1k
Ca2aa a2 0 560p
Ca2c a2 a2c 1u
Ca2cl a2c 0 10p
Ra2p a2c a2pin 470
Ra2in a2pin vcm 40k
Ca2pin a2pin 0 10p
Rb1s tia b1 1k
Rb1g b1 0 1k
Cb1aa b1 0 560p
Cb1c b1 b1c 1u
Cb1cl b1c 0 10p
Rb1p b1c b1pin 470
Rb1in b1pin vcm 40k
Cb1pin b1pin 0 10p
Rb2s lowbuf b2 1k
Rb2g b2 0 1k
Cb2aa b2 0 560p
Cb2c b2 b2c 1u
Cb2cl b2c 0 10p
Rb2p b2c b2pin 470
Rb2in b2pin vcm 40k
Cb2pin b2pin 0 10p
Rsrciso source srcbus 22
Risolo low sum 22
Cstraylo low 0 0.000000000000000000000001
Cstrayhi hi 0 0.000000000000000000000001
Rbridge source probe_f 0.01
Iinj 0 source DC 0 AC 1
Iinj2 0 probe_f DC 0 AC 0
Clocal sum local_cf_out 0.0000000001
Llocal local_cf_out tia 0.00000001
Lfeedback rf_end tia 0.00000011244
.control
set klu
optran 1 0 0 0 0 0
set filetype=ascii
set numdgt=17
op
write final_reverelay_loops_drvstrhigh_srciso22_r100k_open_stray0_risolo22_cng100_caplead10_local100_lead112.44_drive-order0.raw all
quit
.endc
.end
