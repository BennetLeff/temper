RevC final exact full chain; official models; real FDA bias and ADC RC loads
.include ../../sources/ti/models/opa2810_a.lib
.include ../../sources/ti/models/opa810_a.lib
.include ../../sources/ti/models/ths4551.lib
.options reltol=1e-5 abstol=1e-12 vntol=1e-7 method=gear
.include ../solver-resolution-rev-c-final/final-seed.inc
.include OPA2810-internal-probe.lib
Raf2 afbp aim 1k
RF low tia 100000
Cbadc1 badc_p 0 16p
X6A excite source source vp vn OPA2810
Caadc2 aadc_m 0 16p
X6B hi highbuf highbuf vp vn OPA2810_PROBE
Cbadc2 badc_m 0 16p
Cadiff aadc_p aadc_m 3.3n
Rbi2 tia bim 1k
X5 acin srcfb excite vp vn OPA810
Raiso2 afbm aadc_m 4.32
CF low tia 0.000000000005
C36 lp2 acin 1u
Raint1 aom afbm 22
X7B low lowbuf lowbuf vp vn OPA2810
Xb bip bim bop bom cm v5 0 THS4551
Cbdiff badc_p badc_m 3.3n
R31 lp1 lp2 330
Vdds dds0 0 DC 0.3 AC 0
Vp vp 0 12
Rbiso1 bfbp badc_p 4.32
Cfbb2 bfbp bim 100p
R30 dds lp1 330
R34 srcfb 0 1k
Rbint2 bop bfbp 22
Cfba2 afbp aim 100p
Vn vn 0 -12
Xa aip aim aop aom cm v5 0 THS4551
R33 excite srcfb 5k
Raint2 aop afbp 22
Rbf2 bfbp bim 1k
R32 acin 0 100k
Rai2 lowbuf aim 1k
Cbflt2 badc_m 0 330p
Cfba1 afbm aip 100p
X7A 0 low tia vp vn OPA2810
Vcm cm 0 2.048
Rbiso2 bfbm badc_m 4.32
RDUT hi low 100000
V5 v5 0 5
Rbint1 bom bfbm 22
C35 lp2 0 1n
Cfbb1 bfbm bip 100p
C34 lp1 0 1n
RG source hi 100000
Raf1 afbm aip 1k
Caflt1 aadc_p 0 330p
Rbi1 lowbuf bip 1k
Caflt2 aadc_m 0 330p
Cbflt1 badc_p 0 330p
Rbf1 bfbm bip 1k
Rdds dds0 dds 200
Rai1 highbuf aip 1k
Raiso1 afbp aadc_p 4.32
Caadc1 aadc_p 0 16p
.control
set klu
optran 1 0 0 0 0 0
set filetype=ascii
set numdgt=17
op
write final_internal_r100k_high-order10.raw all
quit
.endc
.end
