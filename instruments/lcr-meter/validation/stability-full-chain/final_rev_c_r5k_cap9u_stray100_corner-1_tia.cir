RevC final exact full chain; official models; real FDA bias and ADC RC loads
.include ../../sources/ti/models/opa2810_a.lib
.include ../../sources/ti/models/opa810_a.lib
.include ../../sources/ti/models/ths4551.lib
.options reltol=1e-5 abstol=1e-12 vntol=1e-7 method=gear
.include ../solver-resolution-rev-c-final/final-seed.inc
.nodeset v(probe_f)=0.000100193
Raf2 afbp aim 1k
Cbadc1 badc_p 0 16p
X6A excite source source vp vn OPA2810
Caadc2 aadc_m 0 16p
Cbadc2 badc_m 0 16p
Cadiff aadc_p aadc_m 3.3n
Rbi2 tia bim 1k
X5 acin srcfb excite vp vn OPA810
Raiso2 afbm aadc_m 4.32
Cstraylo low 0 0.0000000001
C36 lp2 acin 1u
Raint1 aom afbm 22
V5 v5 0 4.75
X7B low lowbuf lowbuf vp vn OPA2810
Xb bip bim bop bom cm v5 0 THS4551
X7A 0 probe_f tia vp vn OPA2810
Cbdiff badc_p badc_m 3.3n
Rbridge low probe_f 100
R31 lp1 lp2 330
Vdds dds0 0 DC 0.3 AC 0
Rbiso1 bfbp badc_p 4.32
Cfbb2 bfbp bim 100p
R30 dds lp1 330
R34 srcfb 0 1k
Rbint2 bop bfbp 22
Cfba2 afbp aim 100p
Iinj2 0 probe_f DC 0 AC 0
Xa aip aim aop aom cm v5 0 THS4551
R33 excite srcfb 5k
CDUT hi low 9u
Raint2 aop afbp 22
Rbf2 bfbp bim 1k
R32 acin 0 100k
Vp vp 0 11.399999999999999
Rai2 lowbuf aim 1k
CF low tia 0.0000000000095
Cbflt2 badc_m 0 330p
X6B hi highbuf highbuf vp vn OPA2810
Cfba1 afbm aip 100p
Vcm cm 0 2.048
Cstrayhi hi 0 0.0000000001
Rbiso2 bfbm badc_m 4.32
Vn vn 0 -11.399999999999999
Rbint1 bom bfbm 22
C35 lp2 0 1n
Cfbb1 bfbm bip 100p
C34 lp1 0 1n
Iinj 0 low DC 0 AC 1
Raf1 afbm aip 1k
Caflt1 aadc_p 0 330p
Rbi1 lowbuf bip 1k
RG source hi 4995
Caflt2 aadc_m 0 330p
Cbflt1 badc_p 0 330p
Rbf1 bfbm bip 1k
Rdds dds0 dds 200
Rai1 highbuf aip 1k
RF low tia 5004.999999999999
Raiso1 afbp aadc_p 4.32
Caadc1 aadc_p 0 16p
.control
set klu
optran 1 0 0 0 0 0
set wr_singlescale
set wr_vecnames
set numdgt=17
op
wrdata final_rev_c_r5k_cap9u_stray100_corner-1_tia_dc.dat v(x5.mid) v(x6a.mid) v(x6b.mid) v(x7a.mid) v(x7b.mid) v(xa.mid) v(xb.mid) v(acin) v(source) v(hi) v(low) v(tia) v(highbuf) v(lowbuf) v(aop) v(aom) v(bop) v(bom)
ac dec 120 1 1G
let ve=v(low)
let vf=v(probe_f)
wrdata final_rev_c_r5k_cap9u_stray100_corner-1_tia_e.dat real(ve) imag(ve) real(vf) imag(vf)
alter Iinj ac=0
alter Iinj2 ac=1
ac dec 120 1 1G
let ve=v(low)
let vf=v(probe_f)
wrdata final_rev_c_r5k_cap9u_stray100_corner-1_tia_f.dat real(ve) imag(ve) real(vf) imag(vf)
quit
.endc
.end
