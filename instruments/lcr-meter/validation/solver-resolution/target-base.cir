RevB exact full chain; official models; real FDA bias and ADC RC loads
.include models/opa2810_a.lib
.include models/opa810_a.lib
.include models/ths4551.lib
.options reltol=0.001 method=gear
Vp vp 0 12
Vn vn 0 -12
V5 v5 0 5
Vcm cm 0 2.048
Vdds dds0 0 DC 0.3 AC 1 SIN(0.3 0.3 50k)
Rdds dds0 dds 200
R30 dds lp1 330
C34 lp1 0 1n
R31 lp1 lp2 330
C35 lp2 0 1n
C36 lp2 acin 1u
R32 acin 0 100k
X5 acin srcfb excite vp vn OPA810
R33 excite srcfb 5k
R34 srcfb 0 1k
X6A excite source source vp vn OPA2810
RG source hi 100
CDUT hi low 100n
RF low tia 100
CF low tia 0.000000000000000000000001
X6B hi highbuf high_drv vp vn OPA2810
Vh high_drv highbuf 0
X7B low lowbuf low_drv vp vn OPA2810
Vl low_drv lowbuf 0
X7A 0 low tia_drv vp vn OPA2810
Vt tia_drv tia 0
Rai1 highbuf aip 1k
Rai2 lowbuf aim 1k
Raf1 afbm aip 1k
Raf2 afbp aim 1k
Raint1 aom afbm 3.3
Raint2 aop afbp 3.3
Xa aip aim aop aom cm v5 0 THS4551
Raiso1 aop aadc_p 4.02
Raiso2 aom aadc_m 4.02
Caflt1 aadc_p 0 330p
Caflt2 aadc_m 0 330p
Cadiff aadc_p aadc_m 3.3n
Caadc1 aadc_p 0 16p
Caadc2 aadc_m 0 16p
Rbi1 lowbuf bip 1k
Rbi2 tia bim 1k
Rbf1 bfbm bip 1k
Rbf2 bfbp bim 1k
Rbint1 bom bfbm 3.3
Rbint2 bop bfbp 3.3
Xb bip bim bop bom cm v5 0 THS4551
Rbiso1 bop badc_p 4.02
Rbiso2 bom badc_m 4.02
Cbflt1 badc_p 0 330p
Cbflt2 badc_m 0 330p
Cbdiff badc_p badc_m 3.3n
Cbadc1 badc_p 0 16p
Cbadc2 badc_m 0 16p
.control
set klu
set filetype=ascii
op
write target-base.raw all
quit
.endc
.end
