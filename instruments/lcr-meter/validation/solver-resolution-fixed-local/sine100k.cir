RevC exact full chain; official models; real FDA bias and ADC RC loads
.include models/opa2810_a.lib
.include models/opa810_a.lib
.include models/ths4551.lib
.options reltol=1e-5 abstol=1e-12 vntol=1e-7 method=gear
.include final-seed.inc
Vp vp 0 12
Vn vn 0 -12
V5 v5 0 5
Vcm cm 0 2.048
Vdds dds0 0 DC 0.3 AC 1 SIN(0.3 0.3 100k)
Rdds dds0 dds 200
R30 dds lp1 330
C34 lp1 0 1n
R31 lp1 lp2 330
C35 lp2 0 1n
C36 lp2 acin 1u
R32 acin 0 100k
X5 acin srcfb excite vp vn OPA810
R33 excite srcfb 5k
R34 srcfb 0 1k
X6A excite source source vp vn OPA2810
RG source hi 100000
RDUT hi low 100000
RF low rf_end 100000
CF low cf_end 100p
X6B hi highbuf highbuf vp vn OPA2810
X7B low lowbuf lowbuf vp vn OPA2810
X7A 0 low tia vp vn OPA2810
Rai1 highbuf aip 1k
Rai2 lowbuf aim 1k
Raf1 afbm aip 1k
Raf2 afbp aim 1k
Raint1 aom afbm 22
Raint2 aop afbp 22
Xa aip aim aop aom cm v5 0 THS4551
Raiso1 afbp aadc_p 4.32
Raiso2 afbm aadc_m 4.32
Caflt1 aadc_p 0 330p
Caflt2 aadc_m 0 330p
Cadiff aadc_p aadc_m 3.3n
Caadc1 aadc_p 0 16p
Caadc2 aadc_m 0 16p
Rbi1 lowbuf bip 1k
Rbi2 tia bim 1k
Rbf1 bfbm bip 1k
Rbf2 bfbp bim 1k
Rbint1 bom bfbm 22
Rbint2 bop bfbp 22
Xb bip bim bop bom cm v5 0 THS4551
Rbiso1 bfbp badc_p 4.32
Rbiso2 bfbm badc_m 4.32
Cbflt1 badc_p 0 330p
Cbflt2 badc_m 0 330p
Cbdiff badc_p badc_m 3.3n
Cbadc1 badc_p 0 16p
Cbadc2 badc_m 0 16p
Cfba1 afbm aip 100p
Cfba2 afbp aim 100p
Cfbb1 bfbm bip 100p
Cfbb2 bfbp bim 100p
Lrf rf_end tia 100n
Lcf cf_end tia 5n
Chi hi 0 0.000000000000000000000001
Clo low 0 0.000000000000000000000001
Itest hi low DC 0 AC 0
.control
set klu
optran 1 0 0 0 0 0
optran 1 0 0 0 0 0
set wr_singlescale
set wr_vecnames
set numdgt=17
set filetype=ascii
op
write sine100k_op.raw all
let kh=-i(v.x6b.x_h3.vh_h3)-(v(highbuf)-v(aip))/1000
let kl=-i(v.x7b.x_h3.vh_h3)-(v(lowbuf)-v(aim))/1000-(v(lowbuf)-v(bip))/1000
let kt=-i(v.x7a.x_h3.vh_h3)-(v(tia)-v(low))/100000-(v(tia)-v(bim))/1000
wrdata sine100k_kcl.dat kh kl kt
ac lin 2 1000 100000
let a=v(aadc_p)-v(aadc_m)
let b=v(badc_p)-v(badc_m)
let ratio=b/a
wrdata sine100k_signal.dat real(ratio) imag(ratio) mag(a) mag(b) mag(v(source))
alter Vdds ac=0
alter Itest ac=1
ac lin 1 1 1
wrdata sine100k_step_target.dat real(v(tia)) real(v(highbuf)) real(v(lowbuf))
alter Vdds ac=1
alter Itest ac=0
tran 1n 120u 0 5n
let ihout=-i(v.x6b.x_h3.vh_h3)
let ilout=-i(v.x7b.x_h3.vh_h3)
let itout=-i(v.x7a.x_h3.vh_h3)
wrdata sine100k_tran.dat v(hi) v(low) v(tia) v(highbuf) v(lowbuf) v(aadc_p) v(aadc_m) v(badc_p) v(badc_m) i(Lrf) i(Lcf) ihout ilout itout
quit
.endc
.end
