Rev B wide path with saturating fine branch versus disconnected fine input
.include sources/opa810_a.lib
.include validation/spice/probe_lv.inc
VP VP 0 4.8
VN VN 0 -4.8068
* 0.75V differential at buffered inputs represents 1500V differential probe input.
VBP BP 0 SIN(0 .375 60k)
VBN BN 0 SIN(0 .375 60k 0 0 180)
XON BP BN OUT_ON RAW_ON FINE_ON SEL_ON VP VN PROBE_LV FINE_RANGE=0 BRANCH=1
XOFF BP BN OUT_OFF RAW_OFF FINE_OFF SEL_OFF VP VN PROBE_LV FINE_RANGE=0 BRANCH=0
.control
set wr_singlescale
set wr_vecnames
tran 5n 60u 0 5n
let difference=v(OUT_ON)-v(OUT_OFF)
wrdata validation/spice/unused-fine-saturation.tsv v(OUT_ON) v(OUT_OFF) v(FINE_ON) difference
meas tran worst_difference MAX difference FROM=20u TO=60u
meas tran least_difference MIN difference FROM=20u TO=60u
meas tran fine_max MAX v(FINE_ON) FROM=20u TO=60u
meas tran fine_min MIN v(FINE_ON) FROM=20u TO=60u
quit
.endc
.end
