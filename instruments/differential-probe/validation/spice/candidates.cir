Rev C output-filter candidates (docs/fee-consolidation.md): vendor macromodels, both ranges
.include sources/opa810_a.lib
.include sources/opa2810_a.lib
.include validation/spice/probe_lv.inc
VP VP 0 4.8
VN VN 0 -4.8068
VTP TP 0 DC 0 AC .5
VTN TN 0 DC 0 AC .5 180
* Historical single-pole candidates: JP=0 removes C62.
* A: 97.6 R / 180 pF (before fee consolidation); B: 220 R / 100 pF Basic; C: 100 R Basic / 180 pF.
XWA TP TN OUT_WA RAW_WA FINE_WA SEL_WA VP VN PROBE_LV FINE_RANGE=0 BRANCH=1 R69=97.6 C61=180p JP=0
XFA TP TN OUT_FA RAW_FA FINE_FA SEL_FA VP VN PROBE_LV FINE_RANGE=1 BRANCH=1 R69=97.6 C61=180p JP=0
XWB TP TN OUT_WB RAW_WB FINE_WB SEL_WB VP VN PROBE_LV FINE_RANGE=0 BRANCH=1 R69=220 C61=100p JP=0
XFB TP TN OUT_FB RAW_FB FINE_FB SEL_FB VP VN PROBE_LV FINE_RANGE=1 BRANCH=1 R69=220 C61=100p JP=0
XWC TP TN OUT_WC RAW_WC FINE_WC SEL_WC VP VN PROBE_LV FINE_RANGE=0 BRANCH=1 R69=100 C61=180p JP=0
XFC TP TN OUT_FC RAW_FC FINE_FC SEL_FC VP VN PROBE_LV FINE_RANGE=1 BRANCH=1 R69=100 C61=180p JP=0
.control
set wr_singlescale
set wr_vecnames
ac dec 120 10 100Meg
let wa=mag(v(OUT_WA))
let fa=mag(v(OUT_FA))
let wb=mag(v(OUT_WB))
let fb=mag(v(OUT_FB))
let wc=mag(v(OUT_WC))
let fc=mag(v(OUT_FC))
let pwa=180/PI*vp(OUT_WA)
let pfa=180/PI*vp(OUT_FA)
let pwb=180/PI*vp(OUT_WB)
let pfb=180/PI*vp(OUT_FB)
let pwc=180/PI*vp(OUT_WC)
let pfc=180/PI*vp(OUT_FC)
wrdata validation/spice/candidates.tsv wa fa wb fb wc fc pwa pfa pwb pfb pwc pfc
quit
.endc
.end
