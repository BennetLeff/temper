Rev C vendor macromodel AC comparison: divider, OPA2810 buffers, both ranges
.include sources/opa810_a.lib
.include sources/opa2810_a.lib
.include validation/spice/probe_lv.inc
VP VP 0 4.8
VN VN 0 -4.8068
* 1 V differential at the tips (+/-0.5 V); outputs are ~1/1000 and ~1/200.
VTP TP 0 DC 0 AC .5
VTN TN 0 DC 0 AC .5 180
XW TP TN OUT_W RAW_W FINE_W SEL_W VP VN PROBE_LV FINE_RANGE=0 BRANCH=1
XF TP TN OUT_F RAW_F FINE_F SEL_F VP VN PROBE_LV FINE_RANGE=1 BRANCH=1
.control
set wr_singlescale
set wr_vecnames
ac dec 120 10 100Meg
let wide_mag=mag(v(OUT_W))
let fine_mag=mag(v(OUT_F))
let wide_phase=180/PI*vp(OUT_W)
let fine_phase=180/PI*vp(OUT_F)
wrdata validation/spice/ac.tsv wide_mag fine_mag wide_phase fine_phase
quit
.endc
.end
