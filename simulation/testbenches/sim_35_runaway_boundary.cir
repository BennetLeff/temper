* Runaway Boundary Map + Interlock Margin Verification
* sim_35_runaway_boundary.cir
*
* PURPOSE: Coupled electro-thermal transient testbench that maps the
*          thermal-runaway boundary of the half-bridge IKW40N120H3 IGBTs
*          across a five-parameter sweep (VBUS, K, C_TOL, TAMB, FAN).
*
* APPROACH: Two-time-scale simulation.
*   Electrical: Averaged behavioral half-bridge driving the resonant tank.
*     No cycle-by-cycle IGBT switching - uses envelope model.
*   Thermal: RC ladder network (RthetaJC + RthetaCH + RthetaHA) with
*     power injected from electrical loss computation.
*
* CLASSIFICATION (per SS 2.2 step 3):
*   steady-state: Tj_max < 125 C at end of powered phase AND dTj/dt < 0 post-gate
*   runaway: dTj/dt > +1 C/s post-gate AND Tj_max > 125 C
*   destructive: Tj_max > 175 C at any point
*
*****************************************************************************

.title Runaway Boundary Map - Electro-Thermal Transient

*****************************************************************************
* SIMULATION OPTIONS
*****************************************************************************
.OPTIONS RELTOL=1e-4 ABSTOL=1N VNTOL=1M
.OPTIONS ITL1=300 ITL4=100
.OPTIONS METHOD=TRAP

*****************************************************************************
* INCLUDE MODELS
*****************************************************************************
.INCLUDE ../models/pan_load.sub

*****************************************************************************
* FIXED PARAMETERS (constants, not swept)
*****************************************************************************
.param F_SW=38k
.param DUTY=0.47
.param C_BUS=470u
.param C_RES_NOM=300n
.param L1_UNCOUPLED=80u
.param RCOIL=0.1
.param RPAN_BASE=10

* Thermal parameters (constants)
.param RTH_JC=0.6
.param CTH_JC=50m
.param RTH_CH=0.3
.param CTH_CH=200m
.param RTH_HA_BASE=3.0
.param CTH_HA=1.0

* IGBT loss parameters (IKW40N120H3)
.param R_CE_SAT=0.051
.param VCE0=1.0
.param E_SW_NOM=1.5m
.param TEMPCO_IGBT={0.0035/2.05}

*****************************************************************************
* SWEEP PARAMETERS (loaded from sweep_params.sp; overridden by sweep script)
*****************************************************************************
.INCLUDE sweep_params.sp

*****************************************************************************
* DERIVED PARAMETERS
*****************************************************************************
.param PERIOD={1/F_SW}
.param C_RES={C_RES_NOM * C_TOL}
.param L_EFF={L1_UNCOUPLED * (1 - K*K)}
.param F_RES={1/(2*3.14159*sqrt(L_EFF*C_RES))}
.param R_HA_EFF={FAN < 0.01 ? 1e6 : RTH_HA_BASE / FAN}
.param T_SIM={T_POWERED + T_OBSERVE + 0.001}

*****************************************************************************
* ELECTRICAL: DC BUS + BEHAVIORAL HALF-BRIDGE
*****************************************************************************
V_bus vbus 0 DC {VBUS}
C_bus1 vbus vmid {C_BUS} IC={VBUS/2}
C_bus2 vmid 0 {C_BUS} IC={VBUS/2}
R_mid1 vbus vmid 100k
R_mid2 vmid 0 100k

* Behavioral half-bridge: square wave driving the resonant tank
* Rise/fall at 200ns for simulation speed (edges still fast enough for envelope)
V_bridge mid vmid PULSE({-VBUS/2} {VBUS/2} 0 200n 200n {DUTY*PERIOD} {PERIOD})

* Resonant tank
C_res mid n_cap {C_RES} IC=0
R_cap_esr n_cap n_cap2 0.01
X_pan n_cap2 vmid PANLOAD_VARIABLE L1={L1_UNCOUPLED} K={K} RPAN={RPAN_BASE} RCOIL={RCOIL}

*****************************************************************************
* THERMAL: POWER LOSS COMPUTATION
*****************************************************************************
* Instantaneous tank current (abs value for loss computation)
B_Iabs Iabs 0 V={abs(i(C_res))}
R_Iabs Iabs 0 1MEG

* Temperature-dependent IGBT on-resistance
B_Rce Rce 0 V={R_CE_SAT * (1 + TEMPCO_IGBT * (V(T_junc) - 25))}
R_Rce Rce 0 1MEG

* IGBT conduction loss: P_cond = I * (VCE0 + I * R_ce(Tj))
B_Pcond Pcond 0 V={V(Iabs) * (VCE0 + V(Iabs) * V(Rce))}
R_Pcond Pcond 0 1MEG

* IGBT switching loss: P_sw = E_SW_NOM * (VBUS/340) * (I/40) * F_SW
B_Psw Psw 0 V={E_SW_NOM * (VBUS/340) * (V(Iabs)/40) * F_SW}
R_Psw Psw 0 1MEG

* Total IGBT power dissipation
B_Ptotal Ptotal 0 V={V(Pcond) + V(Psw)}
R_Ptotal Ptotal 0 1MEG

* Gate-active signal: 1.0 during powered phase, 0.0 after
* Uses unit-step to avoid ternary operator parsing issues
B_gate_active gate_active 0 V={u(T_POWERED - time)}
R_gate gate_active 0 1MEG

* Power injection at junction (total IGBT loss)
* Two IGBTs in parallel thermally: R_eff = R_single / 2, C_eff = C_single * 2
B_Pinject 0 T_junc I={V(Ptotal) * V(gate_active)}

*****************************************************************************
* THERMAL: JUNCTION-TO-CASE RC NETWORK (two parallel IGBTs)
*****************************************************************************
* Effective R_jc = 0.6/2 = 0.3, Effective C_jc = 0.05*2 = 0.1
R_jc T_junc N_jc {RTH_JC/2}
C_jc N_jc 0 {CTH_JC*2}

R_ch N_jc T_case {RTH_CH/2}
C_ch T_case 0 {CTH_CH*2}

*****************************************************************************
* THERMAL: CASE-TO-HEATSINK + HEATSINK-TO-AMBIENT
*****************************************************************************
* Both IGBTs share a common heatsink; power flows through thermal resistances
R_hs T_case heatsink 0.1
C_hs heatsink 0 {CTH_HA}

R_ha heatsink amb_node {R_HA_EFF}
V_tamb amb_node 0 DC {TAMB}

*****************************************************************************
* COIL THERMAL MODEL
*****************************************************************************
B_Pcoil 0 coil_Tj I={V(Iabs) * V(Iabs) * RCOIL * V(gate_active)}
R_coil_j coil_Tj T_coil 1.0
C_coil_j T_coil 0 10

R_coil_ha T_coil coil_amb {FAN < 0.01 ? 10 : 1.0 + (1-FAN)*3.0}
V_coil_amb coil_amb 0 DC {TAMB}

*****************************************************************************
* INITIAL CONDITIONS
*****************************************************************************
* Thermal nodes start at ambient temperature
.IC V(T_junc)={TAMB} V(T_case)={TAMB} V(heatsink)={TAMB}

*****************************************************************************
* TRANSIENT SIMULATION
*****************************************************************************
* Run at 100us max step for thermal dynamics; 38kHz smoothed out
.tran 10u {T_SIM} 0 100u uic

*****************************************************************************
* MEASUREMENTS (single-point; classification in control block)
*****************************************************************************
.meas tran Tj_max_val MAX V(T_junc) FROM=0 TO={T_SIM}
.meas tran Tj_max_pw MAX V(T_junc) FROM=0 TO={T_POWERED}
.meas tran Tc_max_pw MAX V(T_case) FROM=0 TO={T_POWERED}
.meas tran Ths_max_pw MAX V(heatsink) FROM=0 TO={T_POWERED}
.meas tran Tcoil_max_pw MAX V(T_coil) FROM=0 TO={T_POWERED}
.meas tran Tj_end_pw FIND V(T_junc) AT={T_POWERED}
.meas tran Tj_end_obs FIND V(T_junc) AT={T_POWERED + T_OBSERVE}
.meas tran Tc_end_pw FIND V(T_case) AT={T_POWERED}
.meas tran Ths_end_pw FIND V(heatsink) AT={T_POWERED}
.meas tran Tcoil_end_pw FIND V(T_coil) AT={T_POWERED}
.meas tran P_diss_end FIND V(Ptotal) AT={T_POWERED * 0.99}

*****************************************************************************
* CONTROL SCRIPT
*****************************************************************************
.control
run

* Classification (computed from measurements in post-processing)
* The .meas results are automatically printed by ngspice in batch mode.
* This control block just prints summary for human readability.

echo "=== SIM35 COMPLETE ==="
echo "VBUS=$&VBUS K=$&K C_TOL=$&C_TOL TAMB=$&TAMB FAN=$&FAN"
echo "Tj_max_val=$&tj_max_val"
echo "Tj_end_pw=$&tj_end_pw"
echo "Tj_end_obs=$&tj_end_obs"
echo "Tc_end_pw=$&tc_end_pw"
echo "Ths_end_pw=$&ths_end_pw"
echo "Tcoil_end_pw=$&tcoil_end_pw"
echo "P_diss_end=$&p_diss_end"

quit
.endc

.end
