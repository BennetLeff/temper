* Half-Bridge Complementary Switching Simulation - Improved
* sim_28_half_bridge_deadtime.cir
*
* PURPOSE: Verify half-bridge operation with dead-time per temper-gqb.2
*
* TEST OBJECTIVES:
* 1. Complementary switching with 500ns dead-time
* 2. Shoot-through prevention verification
* 3. Midpoint voltage excursion (0 to VBUS)
* 4. dV/dt stress measurement
* 5. Current handoff between IGBTs
*
* CONFIGURATION:
*   - DC Bus: 320V (rectified mains)
*   - Switching frequency: 35kHz
*   - Dead-time: 500ns (per temper-gqb.2: 700-1000ns range)
*   - Gate resistor: 2.2Ω (per Robust Bootstrap design)
*   - Load: Inductive (resonant tank representation)
*
***************************************************************************

.title Half-Bridge Complementary Switching with Dead-Time Verification

***************************************************************************
* CONVERGENCE OPTIONS
***************************************************************************
.options reltol=1e-3
.options abstol=1e-9
.options vntol=1e-4
.options gmin=1e-10
.options method=gear
.options maxord=2
.options itl1=500
.options itl2=200
.options itl4=100

***************************************************************************
* INCLUDE IGBT MODEL
***************************************************************************
.include ../models/IKW40N120H3.lib

***************************************************************************
* SIMULATION PARAMETERS
***************************************************************************
.param VDC=320               ; DC bus voltage
.param FREQ=35k              ; Switching frequency
.param PERIOD={1/FREQ}       ; ~28.57us
.param DUTY=0.45             ; Duty cycle per switch
.param T_ON={PERIOD*DUTY}    ; On-time (~12.86us)
.param DT_NS=500             ; Dead-time in ns (per spec: 700-1000ns)
.param DT={DT_NS*1n}         ; Dead-time in seconds

* Gate drive parameters (per Robust Bootstrap design)
.param VGE_ON=15             ; Gate drive voltage
.param RG=2.2                ; Gate resistor (updated from 5Ω to 2.2Ω)
.param RGS=2.2k              ; Gate-source pull-down (Miller immunity)

* Load parameters (simplified inductor for initial test)
.param L_LOAD=100u           ; Load inductance (resonant tank L)
.param R_LOAD=5              ; Load ESR and reflected resistance

***************************************************************************
* POWER SUPPLIES
***************************************************************************
* DC Bus (soft-start to help convergence)
V_dcbus vbus 0 PWL(0 0 10u {VDC} 200u {VDC})

* Bus capacitor (electrolytic + film)
C_bus vbus 0 470u IC=0

* Gate driver supply for low-side
V_vdd_lo vdd_lo 0 DC {VGE_ON}

***************************************************************************
* GATE DRIVE SIGNALS (PWM with Dead-Time)
***************************************************************************
* Using behavioral sources for cleaner gate drive simulation

* High-side gate drive (referenced to midpoint)
* ON during first half of period, OFF during second half + dead-time
V_gate_hi_drv gate_hi_drv midpoint PWL(
+ 0 0
+ {DT/2} 0
+ {DT/2 + 20n} {VGE_ON}
+ {T_ON - DT/2 - 20n} {VGE_ON}
+ {T_ON - DT/2} 0
+ {PERIOD} 0
+ {PERIOD + DT/2} 0
+ {PERIOD + DT/2 + 20n} {VGE_ON}
+ {PERIOD + T_ON - DT/2 - 20n} {VGE_ON}
+ {PERIOD + T_ON - DT/2} 0
+ {2*PERIOD} 0
+ {2*PERIOD + DT/2} 0
+ {2*PERIOD + DT/2 + 20n} {VGE_ON}
+ {2*PERIOD + T_ON - DT/2 - 20n} {VGE_ON}
+ {2*PERIOD + T_ON - DT/2} 0
+ {3*PERIOD} 0
+ {3*PERIOD + DT/2} 0
+ {3*PERIOD + DT/2 + 20n} {VGE_ON}
+ {3*PERIOD + T_ON - DT/2 - 20n} {VGE_ON}
+ {3*PERIOD + T_ON - DT/2} 0
+ {4*PERIOD} 0
+ {4*PERIOD + DT/2} 0
+ {4*PERIOD + DT/2 + 20n} {VGE_ON}
+ {4*PERIOD + T_ON - DT/2 - 20n} {VGE_ON}
+ {4*PERIOD + T_ON - DT/2} 0
+ 200u 0)

* Gate resistor high-side
R_gate_hi gate_hi_drv gate_hi {RG}

* Gate-emitter pull-down for high-side (Miller immunity)
R_gs_hi gate_hi midpoint {RGS}

* Low-side gate drive (referenced to ground)
V_gate_lo_drv gate_lo_drv 0 PWL(
+ 0 0
+ {T_ON + DT/2} 0
+ {T_ON + DT/2 + 20n} {VGE_ON}
+ {PERIOD - DT/2 - 20n} {VGE_ON}
+ {PERIOD - DT/2} 0
+ {PERIOD + T_ON + DT/2} 0
+ {PERIOD + T_ON + DT/2 + 20n} {VGE_ON}
+ {2*PERIOD - DT/2 - 20n} {VGE_ON}
+ {2*PERIOD - DT/2} 0
+ {2*PERIOD + T_ON + DT/2} 0
+ {2*PERIOD + T_ON + DT/2 + 20n} {VGE_ON}
+ {3*PERIOD - DT/2 - 20n} {VGE_ON}
+ {3*PERIOD - DT/2} 0
+ {3*PERIOD + T_ON + DT/2} 0
+ {3*PERIOD + T_ON + DT/2 + 20n} {VGE_ON}
+ {4*PERIOD - DT/2 - 20n} {VGE_ON}
+ {4*PERIOD - DT/2} 0
+ {4*PERIOD + T_ON + DT/2} 0
+ {4*PERIOD + T_ON + DT/2 + 20n} {VGE_ON}
+ 200u {VGE_ON})

* Gate resistor low-side
R_gate_lo gate_lo_drv gate_lo {RG}

* Gate-emitter pull-down for low-side (Miller immunity)
R_gs_lo gate_lo 0 {RGS}

***************************************************************************
* HIGH-SIDE IGBT (Q1)
***************************************************************************
* Collector: vbus
* Gate: gate_hi (referenced to midpoint)
* Emitter: midpoint

X_Q1 vbus gate_hi midpoint IKW40N120H3

***************************************************************************
* LOW-SIDE IGBT (Q2)
***************************************************************************
* Collector: midpoint
* Gate: gate_lo (referenced to 0)
* Emitter: 0 (through sense resistor)

X_Q2 midpoint gate_lo emit_lo IKW40N120H3

* Current sense resistor (1mΩ for minimal impact)
R_sense emit_lo 0 1m

***************************************************************************
* LOAD (Simplified Resonant Tank)
***************************************************************************
* Series RL load to ground (simplified resonant tank)
L_load midpoint load_mid {L_LOAD} IC=0
R_load load_mid 0 {R_LOAD}

***************************************************************************
* ANALYSIS
***************************************************************************
* Run for multiple switching cycles
.tran 5n 150u 0 5n uic

* Initial conditions
.ic V(midpoint)=0
.ic V(vbus)=0

***************************************************************************
* MEASUREMENTS
***************************************************************************
* Window for measurements (skip startup transient)
.param T_START=85u
.param T_END=115u

* --- GATE-EMITTER VOLTAGE (Correct reference) ---
* High-side: V(gate_hi) - V(midpoint) = V(gate_hi, midpoint)
.meas tran V_ge_hi_max MAX v(gate_hi,midpoint) FROM={T_START} TO={T_END}
.meas tran V_ge_hi_min MIN v(gate_hi,midpoint) FROM={T_START} TO={T_END}

* Low-side: V(gate_lo) - V(0) = V(gate_lo)
.meas tran V_ge_lo_max MAX v(gate_lo) FROM={T_START} TO={T_END}
.meas tran V_ge_lo_min MIN v(gate_lo) FROM={T_START} TO={T_END}

* --- MIDPOINT VOLTAGE ---
.meas tran V_mid_max MAX v(midpoint) FROM={T_START} TO={T_END}
.meas tran V_mid_min MIN v(midpoint) FROM={T_START} TO={T_END}
.meas tran V_mid_avg AVG v(midpoint) FROM={T_START} TO={T_END}

* --- dV/dt MEASUREMENT ---
* Rise time (10% to 90% of 320V = 32V to 288V)
.meas tran T_mid_rise_10 WHEN v(midpoint)=32 RISE=3
.meas tran T_mid_rise_90 WHEN v(midpoint)=288 RISE=3
.meas tran T_rise PARAM='T_mid_rise_90 - T_mid_rise_10'
.meas tran DVDT_rise PARAM='(288-32)/T_rise'

* Fall time
.meas tran T_mid_fall_90 WHEN v(midpoint)=288 FALL=3
.meas tran T_mid_fall_10 WHEN v(midpoint)=32 FALL=3
.meas tran T_fall PARAM='T_mid_fall_10 - T_mid_fall_90'
.meas tran DVDT_fall PARAM='(288-32)/T_fall'

* --- DEAD-TIME VERIFICATION ---
* Measure actual dead-time between gate signals
.meas tran T_hi_off WHEN v(gate_hi,midpoint)=5 FALL=3
.meas tran T_lo_on WHEN v(gate_lo)=5 RISE=3
.meas tran DT_actual_1 PARAM='T_lo_on - T_hi_off'

.meas tran T_lo_off WHEN v(gate_lo)=5 FALL=3
.meas tran T_hi_on WHEN v(gate_hi,midpoint)=5 RISE=4
.meas tran DT_actual_2 PARAM='T_hi_on - T_lo_off'

* --- LOAD CURRENT ---
.meas tran I_load_max MAX i(L_load) FROM={T_START} TO={T_END}
.meas tran I_load_min MIN i(L_load) FROM={T_START} TO={T_END}
.meas tran I_load_pp PARAM='I_load_max - I_load_min'

* --- SHOOT-THROUGH CHECK ---
* If both VGE > threshold simultaneously, shoot-through occurs
* Threshold = 5V
* Shoot-through indicator: (V_ge_hi > 5) AND (V_ge_lo > 5)
* We check by finding any time where both gates are high
.meas tran V_both_gates_check FIND v(gate_lo) WHEN v(gate_hi,midpoint)=7 RISE=1

* --- BUS VOLTAGE ---
.meas tran V_bus_max MAX v(vbus) FROM={T_START} TO={T_END}
.meas tran V_bus_min MIN v(vbus) FROM={T_START} TO={T_END}

***************************************************************************
* CONTROL SCRIPT
***************************************************************************
.control
run

echo ""
echo "============================================================"
echo "Half-Bridge Dead-Time Verification - Simulation 28"
echo "============================================================"
echo ""
echo "CONFIGURATION:"
echo "  DC Bus Voltage: 320V"
echo "  Switching Frequency: 35kHz (Period: 28.57us)"
echo "  Duty Cycle: 45% per switch"
echo "  Dead-Time (target): 500ns"
echo "  Gate Resistor: 2.2 ohm"
echo "  Gate Pull-down: 2.2k ohm"
echo "  Load: 100uH + 5 ohm"
echo ""

echo "============================================================"
echo "GATE-EMITTER VOLTAGE (Correct Reference)"
echo "============================================================"
print v_ge_hi_max
print v_ge_hi_min
print v_ge_lo_max
print v_ge_lo_min
echo ""
echo "Target: Max ~15V, Min ~0V for both"
echo ""

echo "============================================================"
echo "MIDPOINT (SWITCH NODE) VOLTAGE"
echo "============================================================"
print v_mid_max
print v_mid_min
print v_mid_avg
echo ""
echo "Target: Max ~320V (VBUS), Min ~0V, Avg ~144V (45% duty)"
echo ""

echo "============================================================"
echo "dV/dt AT SWITCH NODE"
echo "============================================================"
print t_rise
print dvdt_rise
print t_fall
print dvdt_fall
echo ""
echo "Units: seconds, V/s"
echo "Target dV/dt: <10V/ns for EMI, >1V/ns for efficiency"
echo "CMTI requirement: UCC21550 rated for 125V/ns"
echo ""

echo "============================================================"
echo "DEAD-TIME VERIFICATION"
echo "============================================================"
print dt_actual_1
print dt_actual_2
echo ""
echo "Target: ~500ns (range: 700-1000ns acceptable)"
echo ""

echo "============================================================"
echo "SHOOT-THROUGH CHECK"
echo "============================================================"
print v_both_gates_check
echo ""
echo "If this shows low-side gate voltage when high-side is ON:"
echo "  < 5V = SAFE (no shoot-through)"
echo "  > 5V = DANGER (potential shoot-through)"
echo ""

echo "============================================================"
echo "LOAD CURRENT"
echo "============================================================"
print i_load_max
print i_load_min
print i_load_pp
echo ""

echo "============================================================"
echo "BUS VOLTAGE"
echo "============================================================"
print v_bus_max
print v_bus_min
echo ""

echo "============================================================"
echo "SUMMARY"
echo "============================================================"
echo ""
echo "Half-bridge dead-time verification complete."
echo "Check that:"
echo "  1. VGE(hi) and VGE(lo) reach ~15V max, ~0V min"
echo "  2. Midpoint swings 0V to 320V"
echo "  3. Dead-time is positive (~500ns)"
echo "  4. No shoot-through (both gates not high simultaneously)"
echo "  5. dV/dt is within acceptable range"
echo ""

* Generate plots
set hcopydevtype=svg
hardcopy sim_28_gate_voltages.svg v(gate_hi,midpoint) v(gate_lo) title 'Gate-Emitter Voltages'
hardcopy sim_28_midpoint.svg v(midpoint) title 'Midpoint (Switch Node) Voltage'
hardcopy sim_28_combined.svg v(midpoint)/20 v(gate_hi,midpoint) v(gate_lo) i(L_load) title 'Combined Waveforms'

quit
.endc

.end
