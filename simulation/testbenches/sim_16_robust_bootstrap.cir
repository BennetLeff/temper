* Simulation 16: Robust Bootstrap Circuit Verification
* ============================================================================
* Purpose: Verify robust bootstrap circuit for Control Freak-class induction
*          cooker with burst mode operation and Miller effect protection
*
* Test Objectives:
* 1. Verify bootstrap charging during low-side ON (target: <10us to 14.6V)
* 2. Verify voltage droop during burst mode (100 pulses + 2s sleep)
* 3. Verify Miller current immunity with 2.2kOhm pull-down (target: V_GE < 3V)
* 4. Verify UVLO margin stays above 8.5V (UCC21550B threshold)
* 5. Verify 10uF C_BOOT provides adequate hold time for burst sleep
*
* Design Under Test: Robust Bootstrap V1
* - C_BOOT: 10uF (vs 1uF original)
* - RGS: 2.2kOhm (vs 10kOhm original) for Miller immunity
* - UCC21550B variant (8.5V UVLO vs 6.0V)
*
* References:
* - SPLIT_RAIL_BOOTSTRAP_DESIGN.md (complete design document)
* - BOOTSTRAP_BURST_MODE_ANALYSIS.md (capacitor sizing)
* - MILLER_CURRENT_ANALYSIS.md (pull-down resistor selection)
* - GATE_DRIVER_POWER_ARCHITECTURE_DECISION.md (Addendum)
*
* Related Tasks: temper-8l2.6, temper-8l2 (Bootstrap Supply Safety Epic)
* ============================================================================

.title Robust Bootstrap Circuit Verification - sim_16_robust_bootstrap.cir

* ============================================================================
* SIMULATION PARAMETERS
* ============================================================================

* Power supply
.param VDD=15                   ; Auxiliary supply voltage
.param VDC=300                  ; DC bus voltage (rectified mains)

* Robust bootstrap design (V1)
.param CBOOT=10u                ; Bootstrap capacitance (10x increase from 1uF)
.param RGS=2.2k                 ; Gate-source pull-down (Miller immunity)
.param RG_ON=2.2                ; Gate turn-on resistor
.param VF_DBOOT=0.4             ; Bootstrap diode forward drop (SiC Schottky)

* IGBT parameters (IKW40N120H3)
.param CG_TOTAL=7.5n            ; Total gate capacitance (CGE + CGC)
.param CGD=130p                 ; Gate-drain (Miller) capacitance
.param VGE_TH=5.0               ; Gate threshold voltage

* Switching parameters
.param FREQ=50kHz               ; Switching frequency
.param PERIOD={1/FREQ}          ; 20us
.param DUTY=0.45                ; Duty cycle (45% typical for resonant)
.param T_ON={PERIOD*DUTY}       ; High-side on-time

* dV/dt for Miller analysis
.param DVDT_TYPICAL=6e9         ; 6 V/ns typical (300V/50ns)
.param DVDT_FAST=15e9           ; 15 V/ns fast switching

* Driver parameters
.param UVLO_B=8.5               ; UCC21550B UVLO threshold
.param UVLO_A=6.0               ; UCC21550A UVLO threshold (for comparison)
.param I_QUIESCENT=5m           ; Driver quiescent current

* ============================================================================
* TEST 1: BOOTSTRAP CHARGING AND NORMAL OPERATION
* ============================================================================
* Verifies bootstrap charges to VDD-VF within 10us during low-side ON

* Power supply
V_VDD VDD_15V 0 DC {VDD}

* Bootstrap diode (SiC Schottky model)
D_BOOT VDD_15V N_BOOT D_SIC_SCHOTTKY
.model D_SIC_SCHOTTKY D(IS=1e-15 N=1.1 RS=0.02 BV=1200 VJ=0.9)

* Bootstrap capacitor (10uF)
C_BOOT N_BOOT SW {CBOOT} IC=0

* Quiescent current drain (models driver current consumption)
I_Q N_BOOT SW DC {I_QUIESCENT}

* Switch node (simplified half-bridge)
* PWM signal: LOW = 0V (LS on, bootstrap charging), HIGH = 300V (HS on)
V_SW_PWM SW_CTRL 0 PULSE(0 1 0 50n 50n {T_ON} {PERIOD})

* Switch node voltage (behavioral)
E_SW SW 0 VALUE={V(SW_CTRL) > 0.5 ? VDC : 0}

* ============================================================================
* TEST 2: GATE DRIVE OUTPUT AND MILLER EFFECT
* ============================================================================
* Simulates gate driver output with Miller current injection

* Simplified gate driver output (behavioral UCC21550)
* Output HIGH when driver on and bootstrap above UVLO
E_DRIVER_OUT OUTA SW VALUE={
+   V(N_BOOT,SW) > UVLO_B ?
+     (V(DRV_CTRL) > 0.5 ? V(N_BOOT,SW) : 0)
+   : 0
+}

* Driver control signal (HIGH when high-side should be ON)
V_DRV_CTRL DRV_CTRL 0 PULSE(0 1 {PERIOD/4} 10n 10n {T_ON-20n} {PERIOD})

* Gate drive resistor
R_G_ON OUTA N_GATE {RG_ON}

* IGBT gate capacitance
C_GATE N_GATE SW {CG_TOTAL}

* Gate-source pull-down (2.2kOhm for Miller immunity)
R_GS N_GATE SW {RGS}

* Miller capacitor (gate-drain)
C_MILLER N_GATE N_COLLECTOR {CGD}

* Collector follows switch node (for Miller current injection)
E_COLLECTOR N_COLLECTOR 0 SW 0 1

* ============================================================================
* TEST 3: BURST MODE OPERATION (LONG SLEEP)
* ============================================================================
* This test requires longer simulation - use .param to select test mode
*
* For quick test (normal switching): BURST_MODE=0
* For burst mode test (2s sleep): BURST_MODE=1 (requires long sim time!)

.param BURST_MODE=0             ; Set to 1 for burst mode test

* Note: For burst mode droop analysis, calculate analytically:
* V_droop = (I_quiescent * t_sleep) / C_BOOT
* At 2s sleep: V_droop = (5mA * 2s) / 10uF = 1.0V
* Final voltage: 14.6V - 1.0V = 13.6V >> 8.5V (PASS)

* ============================================================================
* BEHAVIORAL VOLTAGE SOURCES FOR MEASUREMENTS
* ============================================================================
* ngspice doesn't support V(node1) - V(node2) syntax in .meas statements
* Create behavioral sources to measure differential voltages

* Bootstrap voltage relative to switch node
B_VBOOT V_BOOT_DIFF 0 V=V(N_BOOT)-V(SW)

* Gate voltage relative to switch node
B_VGATE V_GATE_DIFF 0 V=V(N_GATE)-V(SW)

* ============================================================================
* ANALYSIS
* ============================================================================

* Transient analysis - 10 switching cycles (200us)
.tran 0.1u 200u 0 0.1u UIC

* ============================================================================
* MEASUREMENTS
* ============================================================================

* ----- Bootstrap Voltage Measurements -----

* Maximum bootstrap voltage (should reach VDD - VF = 14.6V)
.meas tran V_BOOT_MAX MAX V(V_BOOT_DIFF)

* Minimum bootstrap voltage during operation (after first few cycles)
.meas tran V_BOOT_MIN MIN V(V_BOOT_DIFF) FROM=50u TO=200u

* Bootstrap droop during high-side ON (single cycle)
.meas tran V_BOOT_PRE_HS FIND V(V_BOOT_DIFF) AT=100u
.meas tran V_BOOT_POST_HS FIND V(V_BOOT_DIFF) AT=109u
.meas tran V_BOOT_DROOP PARAM='V_BOOT_PRE_HS - V_BOOT_POST_HS'

* Bootstrap charging time (0 to 90% of final)
.meas tran T_CHARGE_90 WHEN V(V_BOOT_DIFF)=13.14 RISE=1

* ----- Gate Voltage Measurements -----

* Gate voltage HIGH (should be ~14.6V when driver on)
.meas tran V_GATE_ON_MAX MAX V(V_GATE_DIFF) FROM=50u TO=200u

* Gate voltage LOW (should be ~0V when driver off)
.meas tran V_GATE_OFF_MIN MIN V(V_GATE_DIFF) FROM=50u TO=200u

* Miller effect peak (during dV/dt transient)
* NOTE: This simplified behavioral model does not accurately capture Miller effect
* because E_COLLECTOR directly follows SW node without dV/dt-dependent current injection.
* The Miller immunity is validated analytically:
*   I_Miller = CGD * dV/dt = 130pF * 6V/ns = 0.78mA
*   V_peak = I_Miller * RGS = 0.78mA * 2.2kOhm = 1.7V (SAFE << 5V threshold)
* For detailed Miller transient simulation, use full IGBT model with CGD nonlinearity.
* Measure gate voltage during OFF state to verify pull-down holds gate low
.meas tran V_GATE_OFF_WORST MAX V(V_GATE_DIFF) FROM=0u TO=4.9u

* ----- Miller Current Analysis -----

* Theoretical Miller current: I = CGD * dV/dt
* With 6V/ns: I = 130pF * 6V/ns = 0.78mA
* With 2.2k pull-down: V_rise = 0.78mA * 2.2k = 1.7V (SAFE < 5V)

* Note: Gate pull-down current not directly measurable in this simplified model

* ----- UVLO Margin Analysis -----

* Check if bootstrap stays above UVLO_B threshold
.meas tran UVLO_MARGIN_MIN PARAM='V_BOOT_MIN - 8.5'

* Check against UVLO_A for comparison (would be unsafe!)
.meas tran UVLO_MARGIN_A PARAM='V_BOOT_MIN - 6.0'

* ============================================================================
* PASS/FAIL CRITERIA
* ============================================================================
*
* PASS CRITERIA:
* 1. V_BOOT_MAX >= 14.0V (bootstrap charges adequately)
* 2. V_BOOT_MIN >= 9.5V (stays above UVLO_B + 1V margin)
* 3. V_GATE_ON_MAX >= 14.0V (adequate IGBT saturation)
* 4. V_GATE_MILLER_PEAK < 3.0V (Miller immunity - 2V margin to threshold)
* 5. T_CHARGE_90 < 10us (fast bootstrap charging)
* 6. UVLO_MARGIN_MIN > 1.0V (safety margin above UVLO)
*
* FAIL CRITERIA:
* - V_BOOT_MIN < 8.5V (UVLO would trigger)
* - V_GATE_MILLER_PEAK > 5.0V (would falsely turn on IGBT)

* ============================================================================
* SIMULATION CONTROL AND OUTPUT
* ============================================================================

.control
run

echo ""
echo "============================================"
echo "Robust Bootstrap Circuit Verification"
echo "Simulation 16 Results"
echo "============================================"
echo ""
echo "Design Configuration:"
echo "  C_BOOT: 10uF (robust, vs 1uF standard)"
echo "  RGS: 2.2kOhm (Miller immune, vs 10kOhm standard)"
echo "  UCC21550B UVLO: 8.5V (fail-safe, vs 6.0V A variant)"
echo "  VDD: 15V, VDC: 300V, Freq: 50kHz"
echo ""
echo "--------------------------------------------"
echo "BOOTSTRAP VOLTAGE PERFORMANCE"
echo "--------------------------------------------"
print v_boot_max v_boot_min v_boot_droop
echo ""
echo "  Target V_BOOT_MAX: >= 14.0V (VDD - diode drop)"
echo "  Target V_BOOT_MIN: >= 9.5V (UVLO_B + 1V margin)"
echo "  Acceptable droop/cycle: < 1.0V"
echo ""
echo "UVLO MARGIN ANALYSIS:"
print uvlo_margin_min uvlo_margin_a
echo ""
echo "  UVLO_B threshold: 8.5V"
echo "  Minimum margin above UVLO_B: should be > 1.0V"
echo "  (UVLO_A margin shown for comparison - would be unsafe!)"
echo ""
echo "--------------------------------------------"
echo "BOOTSTRAP CHARGING PERFORMANCE"
echo "--------------------------------------------"
print t_charge_90
echo ""
echo "  Target: < 10us to reach 90% of final voltage"
echo ""
echo "--------------------------------------------"
echo "GATE VOLTAGE PERFORMANCE"
echo "--------------------------------------------"
print v_gate_on_max v_gate_off_min
echo ""
echo "  Target V_GATE_ON: >= 14.0V (IGBT saturation)"
echo "  Target V_GATE_OFF: < 0.5V (fully off)"
echo ""
echo "--------------------------------------------"
echo "MILLER EFFECT IMMUNITY (Analytical)"
echo "--------------------------------------------"
print v_gate_off_worst
echo ""
echo "  NOTE: Simplified model - Miller transient not captured"
echo "  Analytical validation (see MILLER_CURRENT_ANALYSIS.md):"
echo "    I_Miller = CGD * dV/dt = 130pF * 6V/ns = 0.78mA"
echo "    V_peak = 0.78mA * 2.2kOhm = 1.7V"
echo "  Result: 1.7V << 5.0V (VGE_th) - PASS with 3.3V margin"
echo ""
echo "--------------------------------------------"
echo "BURST MODE ANALYSIS (Calculated)"
echo "--------------------------------------------"
echo "  C_BOOT: 10uF"
echo "  I_quiescent: 5mA"
echo "  Sleep time for 1V droop: t = C*V/I = 10uF*1V/5mA = 2.0s"
echo "  Maximum safe sleep: 18s (droop to 9V, above UVLO_B)"
echo ""
echo "  Control Freak burst sleep: typically 100ms - 2s"
echo "  Verdict: 10uF provides adequate margin (PASS)"
echo ""
echo "============================================"
echo "PASS/FAIL SUMMARY"
echo "============================================"
echo ""

* Check pass/fail conditions using measurement results
* Note: ngspice requires single & for AND, but has issues with spaces
* Simplified pass/fail without complex boolean logic

echo "Checking results against criteria..."
echo ""

* Simply print the results - manual verification
echo "  V_BOOT_MAX target: >= 14.0V"
echo "  V_BOOT_MIN target: >= 9.5V"
echo "  V_GATE_ON_MAX target: >= 14.0V"
echo "  V_GATE_OFF_WORST target: < 0.5V (pull-down effective)"
echo "  T_CHARGE_90 target: < 10us"
echo "  UVLO_MARGIN target: > 1.0V"
echo "  Miller immunity: 1.7V analytical (PASS)"
echo ""
echo "  Review measurements above to verify PASS/FAIL"

echo ""
echo "============================================"
echo "END OF SIMULATION"
echo "============================================"

* Note: Plot commands removed for batch mode compatibility
* Run interactively for waveform viewing:
*   ngspice sim_16_robust_bootstrap.cir
*   plot V(V_BOOT_DIFF) V(SW)/20
*   plot V(V_GATE_DIFF) V(SW)/20

quit
.endc

* ============================================================================
* EXTENDED TEST: BURST MODE DROOP (optional - requires long sim)
* ============================================================================
* Uncomment this section and increase simulation time for burst mode test
*
*.param SLEEP_TIME=2s
*.tran 1m {SLEEP_TIME+10m} 0 1m UIC
*
* This would verify:
* - Bootstrap holds above UVLO during 2s sleep
* - V_droop = I_Q * t / C = 5mA * 2s / 10uF = 1.0V
* - Final: 14.6V - 1.0V = 13.6V >> 8.5V UVLO

.end
