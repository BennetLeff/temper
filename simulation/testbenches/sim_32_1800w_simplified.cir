* 1800W System Verification - Simplified Model
* sim_32_1800w_simplified.cir
*
* PURPOSE: Verify 1800W operating point using simplified half-bridge model
*          to avoid IGBT model convergence issues.
*
* This uses behavioral voltage source for half-bridge to focus on
* resonant tank behavior at 1800W operating point.
*
***************************************************************************

.title 1800W Induction Cooker - Simplified System Verification

***************************************************************************
* PARAMETERS
***************************************************************************
.param VDC=170              ; DC bus (120VAC rectified)
.param F_SW=35.8k           ; At resonance for maximum power
.param P_TARGET=1800        ; Target power
.param PERIOD={1/F_SW}
.param DUTY=0.50            ; 50% duty at resonance

* Tank parameters
.param C_RES=330n
.param L_EFF=60u
.param R_PAN=8
.param R_COIL=0.22

***************************************************************************
* SIMPLIFIED HALF-BRIDGE (behavioral square wave)
***************************************************************************
* Models the midpoint voltage as ideal square wave
V_bridge midpoint 0 PULSE(0 {VDC} 0 10n 10n {DUTY*PERIOD} {PERIOD})

***************************************************************************
* RESONANT TANK
***************************************************************************
C_res midpoint n_cap {C_RES} IC=0
R_esr n_cap n_cap2 0.01

L_coil n_cap2 n_l {L_EFF} IC=0
R_coil n_l n_r {R_COIL}
R_pan n_r 0 {R_PAN}

***************************************************************************
* ANALYSIS
***************************************************************************
.tran 100n 10m 0 100n uic

.param T_START=8m
.param T_END=10m

.meas tran I_rms RMS i(L_coil) FROM={T_START} TO={T_END}
.meas tran I_peak MAX i(L_coil) FROM={T_START} TO={T_END}
.meas tran I_min MIN i(L_coil) FROM={T_START} TO={T_END}
.meas tran V_cap_peak MAX v(n_cap) FROM={T_START} TO={T_END}

***************************************************************************
* CONTROL
***************************************************************************
.control
run

let i_tank = i(l_coil)
meas tran i_rms_val RMS i_tank from=8m to=10m
meas tran i_peak_val MAX i_tank from=8m to=10m

let r_pan = 8
let r_coil = 0.22
let p_pan = i_rms_val * i_rms_val * r_pan
let p_coil = i_rms_val * i_rms_val * r_coil
let p_total = p_pan + p_coil
let eff = p_pan / p_total * 100

echo ""
echo "============================================================"
echo "1800W SYSTEM VERIFICATION - Simulation 32 (Simplified)"
echo "============================================================"
echo ""
echo "SYSTEM CONFIGURATION:"
echo "  DC Bus: 170V (120VAC rectified)"
echo "  Switching Frequency: 38 kHz"
echo "  Target Power: 1800W"
echo "  Resonant Cap: 330 nF"
echo "  Effective Inductance: 60 uH"
echo "  Pan Resistance: 8 ohm"
echo "  Coil Resistance: 0.22 ohm"
echo ""

echo "============================================================"
echo "CURRENT MEASUREMENTS"
echo "============================================================"
print i_rms_val
print i_peak_val
echo ""
echo "Target for 1800W: I_rms = 15.0A, I_peak = 21.2A"
echo ""

echo "============================================================"
echo "POWER ANALYSIS"
echo "============================================================"
print p_pan
print p_coil
print p_total
print eff
echo ""

echo "============================================================"
echo "THERMAL SUMMARY (1800W)"
echo "============================================================"
echo ""
echo "Coil I²R loss:"
print p_coil
echo ""
echo "IGBT losses (from detailed analysis):"
echo "  At 170V bus with ZVS:"
echo "  - Conduction: ~24W (I² lower than 320V case)"
echo "  - Switching: ~8W (ZVS, voltage-proportional)"
echo "  - Diode: ~6W"
echo "  - Total IGBT: ~38W"
echo ""
echo "TOTAL HEAT BUDGET:"
let total_heat = 38 + p_coil
print total_heat
echo ""

echo "============================================================"
echo "CAPACITOR STRESS"
echo "============================================================"
print v_cap_peak
echo "Rating required: 400V minimum (use 630V for margin)"
echo ""

echo "============================================================"
echo "VERIFICATION STATUS"
echo "============================================================"
echo ""
echo "Checking against 1800W target..."
echo ""

quit
.endc

.end
