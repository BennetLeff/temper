*******************************************************************************
* Lesson 15: LDO Verification for ESP32-S3 Power Supply
* Task: temper-pt8
* Purpose: Verify 5V→3.3V LDO performance
* Selected Part: XC6220B331MR-G (Torex) - 6.5µV noise, 75dB PSRR
*******************************************************************************

.TITLE XC6220 3.3V LDO Verification

*------------------------------------------------------------------------------
* Options
*------------------------------------------------------------------------------
.OPTIONS RELTOL=0.003 ABSTOL=1N VNTOL=1M
.OPTIONS ITL1=500 ITL4=200

*******************************************************************************
* DESIGN SPECIFICATIONS
*******************************************************************************
* Input: 5V DC (from LMR51430 buck converter)
* Output: 3.3V DC
* Load: 100mA typical, 380mA peak (ESP32 WiFi burst)
* Noise: <50µV RMS (10Hz-100kHz) - XC6220 spec: 6.5µV
* PSRR: >60dB @ 1kHz - XC6220 spec: 75dB
*******************************************************************************

*------------------------------------------------------------------------------
* 5V INPUT SUPPLY (with buck converter ripple)
* LMR51430 @ 1.1MHz produces ~20mV ripple
*------------------------------------------------------------------------------
V5V N_5V_IDEAL 0 DC 5.0
* Add ripple: 20mV @ 1.1MHz switching frequency
VRIPPLE N_5V_IDEAL N_5V SIN(0 0.02 1.1MEG)

*------------------------------------------------------------------------------
* INPUT CAPACITOR (10µF ceramic)
*------------------------------------------------------------------------------
CIN N_5V 0 10U IC=5

*------------------------------------------------------------------------------
* LDO MODEL (XC6220B331 Behavioral)
* Simple but effective: regulates to 3.3V with PSRR and load response
*------------------------------------------------------------------------------
* Error amplifier: regulates VOUT to 3.3V reference
* Gain of 100 provides good regulation without oscillation
ELDO N_REG 0 VALUE={LIMIT(3.3 + (3.3 - V(N_3V3))*100, 0, V(N_5V)-0.16)}

* Pass element - low output impedance
RPASS N_REG N_LDO_OUT 0.015

* PSRR injection: 75dB = 1/5623 attenuation at DC
* Small fraction of input ripple passes through
GPSRR 0 N_LDO_OUT VALUE={V(N_5V)*0.000178}

*------------------------------------------------------------------------------
* OUTPUT CAPACITOR (22µF ceramic)
* Connected between LDO output and ground
*------------------------------------------------------------------------------
COUT N_LDO_OUT 0 22U IC=3.3

*------------------------------------------------------------------------------
* OUTPUT NODE (after ESR)
*------------------------------------------------------------------------------
RESR N_LDO_OUT N_3V3 0.005

*------------------------------------------------------------------------------
* LOAD MODEL
* Base: 100mA (ESP32 idle + peripherals) → 33Ω at 3.3V
* Step: +280mA at t=50ms (WiFi TX burst, 100ms duration)
*------------------------------------------------------------------------------
RLOAD N_3V3 0 33

* Load step using PWL current source
ILOAD N_3V3 0 PWL(
+ 0 0
+ 49.9M 0
+ 50M 0.28
+ 150M 0.28
+ 150.1M 0
+ 200M 0
+ )

*------------------------------------------------------------------------------
* ANALYSIS
*------------------------------------------------------------------------------
* Transient: 200ms to see load step response
.TRAN 1U 200M 0 1U UIC

*------------------------------------------------------------------------------
* MEASUREMENTS
*------------------------------------------------------------------------------
.MEAS TRAN V3V3_AVG AVG V(N_3V3) FROM=10M TO=49M
.MEAS TRAN V3V3_RIPPLE PP V(N_3V3) FROM=40M TO=49M
.MEAS TRAN V3V3_LOADED AVG V(N_3V3) FROM=100M TO=149M
.MEAS TRAN V3V3_UNDERSHOOT MIN V(N_3V3) FROM=49M TO=60M
.MEAS TRAN V3V3_OVERSHOOT MAX V(N_3V3) FROM=149M TO=160M
.MEAS TRAN V5V_AVG AVG V(N_5V) FROM=10M TO=49M

*------------------------------------------------------------------------------
* CONTROL SCRIPT
*------------------------------------------------------------------------------
.CONTROL

set filetype=ascii
set color0=white
set color1=black

echo ""
echo "============================================================"
echo "  XC6220 3.3V LDO Verification"
echo "  5V Input, 3.3V Output"
echo "  Load: 100mA base + 280mA step (WiFi burst)"
echo "============================================================"
echo ""

run

echo ""
echo "============================================================"
echo "MEASUREMENT RESULTS:"
echo "============================================================"

print v5v_avg
print v3v3_avg v3v3_loaded
print v3v3_ripple
print v3v3_undershoot v3v3_overshoot

echo ""
echo "============================================================"
echo "LOAD REGULATION CALCULATION:"
echo "============================================================"

let v_drop = v3v3_avg - v3v3_loaded
let load_reg = v_drop / 0.28 * 1000
echo "Voltage drop (light to heavy): "
print v_drop
echo "Load regulation (mV/A): "
print load_reg

echo ""
echo "============================================================"
echo "VERIFICATION SUMMARY:"
echo "============================================================"
echo ""
echo "Target 1: Output Voltage 3.3V +/- 2% (3.234V - 3.366V)"

if v3v3_avg > 3.23 & v3v3_avg < 3.37
  echo "  PASS - Light load: in range"
else
  echo "  FAIL - Light load: out of range"
end

if v3v3_loaded > 3.23 & v3v3_loaded < 3.37
  echo "  PASS - Heavy load (380mA): in range"
else
  echo "  FAIL - Heavy load: out of range"
end

echo ""
echo "Target 2: Output Ripple < 10mV (from 1.1MHz buck)"

if v3v3_ripple < 0.01
  echo "  PASS - Ripple well controlled"
else if v3v3_ripple < 0.05
  echo "  ACCEPTABLE - Ripple under 50mV"
else
  echo "  CHECK - Ripple higher than expected"
end

echo ""
echo "Target 3: Load Regulation < 50mV/A"

if load_reg < 50
  echo "  PASS - Good load regulation"
else
  echo "  CHECK - Load regulation needs review"
end

echo ""
echo "Target 4: Load Transient Response"
echo "  Undershoot limit: > 3.0V (< 300mV drop)"
echo "  Overshoot limit: < 3.5V (< 200mV rise)"

if v3v3_undershoot > 3.0
  echo "  PASS - Undershoot acceptable"
else
  echo "  CHECK - Excessive undershoot during load step"
end

if v3v3_overshoot < 3.5
  echo "  PASS - Overshoot acceptable"
else
  echo "  CHECK - Excessive overshoot during load release"
end

echo ""
echo "============================================================"
echo "SELECTED COMPONENT: XC6220B331MR-G (Torex)"
echo "============================================================"
echo "Output Voltage: 3.3V"
echo "Max Current: 700mA (vs 380mA required = 84% margin)"
echo "Noise: 6.5uV RMS (vs 50uV requirement = 7.7x better)"
echo "PSRR @ 1kHz: 75dB (vs 60dB requirement = 15dB margin)"
echo "PSRR @ 100kHz: 60dB (vs 40dB requirement = 20dB margin)"
echo "Dropout @ 380mA: 160mV (vs 1.7V available headroom)"
echo "Package: SOT-25 (2.9mm x 2.8mm)"
echo "Quiescent Current: 8uA"
echo ""
echo "ALTERNATIVE: TLV75733PDBVR (Texas Instruments)"
echo "  - 1A max current, 18uV noise, SOT-23-5"
echo "  - Better availability, similar performance"
echo "============================================================"

wrdata sim_15_results.txt v(n_5v) v(n_3v3) v(n_ldo_out)

.ENDC

.END
