*****************************************************************************
* Test Circuit: UCC14140-Q1 Isolated Supply
* Task: temper-37v.8
* Purpose: Verify startup and CMTI performance of isolated gate drive supply
******************************************************************************

.TITLE UCC14140-Q1 High-Side Supply Test

.INCLUDE ../../simulation/models/UCC14140_behavioral.sub
.INCLUDE common_options.spice

*------------------------------------------------------------------------------
* Circuit Definition
*------------------------------------------------------------------------------
* Parameters
.param C_ISO_VAL=3.5p

* 12V input
Vin vin 0 DC 12

* UCC14140-Q1
* Pins: VIN GNDP VDD VEE COM ENA PG
X1 vin 0 vdd vee com ena pg UCC14140_BEHAVIORAL PARAMS: VOUT_VDD=22 VOUT_COM=4

* Enable
Vena ena 0 PULSE(0 5 1m 1n 1n 100m 200m)

* Load
R_load vdd vee 1k

* CMTI Stress Test
* 400V pulse with 10ns rise time -> 40V/ns.
Vsw vee 0 PULSE(0 400 5m 10n 10n 50u 100u)

*------------------------------------------------------------------------------
* Analysis
*------------------------------------------------------------------------------
.tran 100n 6m

*------------------------------------------------------------------------------
* Control Block for automated measurement
*------------------------------------------------------------------------------
.control
run
print Tstart I_cmti
* Measure Startup Time
meas tran Tstart WHEN v(vdd,vee)=19.8 RISE=1
* Measure CMTI Current Peak
meas tran I_cmti MAX i(Vsw) FROM=5m TO=5.001m
.endc

.END
