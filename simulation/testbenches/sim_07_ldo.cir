* 5V to 3.3V LDO with Pi-Filter Input
* Lesson 07

* Circuit Description
* Input: 5V DC + 1V AC (for Transfer Function Analysis)
Vin 5v_noisy 0 DC 5 AC 1

* Pi-filter
* C1=10u, L=1u, C2=10u
C1 5v_noisy 0 10u
L1 5v_noisy 5v_clean 1u
C2 5v_clean 0 10u

* LDO Model (Simplified)
* Vout = 3.3V + (Vin - 3.3V) / 10^(PSRR_dB/20)
* Typical LDO PSRR = 60dB at low freq, drops at high freq.
* Let's model PSRR as a frequency dependent source?
* Or just a fixed attenuation for now, combined with filter?
* The exercise is to verify the FILTER attenuation + LDO rejection.
* If LDO has 40dB rejection at 1MHz (typical for good LDO), and filter adds 40dB...
* Let's model LDO as a VCVS with PSRR transfer function.
* PSRR(f) = 60dB / (1 + f/10k) ?
* Simplification: E_ldo Vout 0 VALUE = {3.3 + v(5v_clean, 0)*0.001} (60dB constant)
* Real LDO:
* PMOS Pass element. Error Amp.
* Let's use the curriculum's simple model:
* E_ldo 3v3 0 VALUE = {3.3 + V(5v_clean,3.3)/1000} -> This injects ripple.
* Note: V(5v_clean, 3.3) means V(5v_clean) - V(node 3.3)? No node 3.3.
* It meant V(5v_clean) relative to 3.3V DC?
* The ripple is small AC.
* E_ldo 3v3 0 VALUE = {3.3 + V(5v_clean)*0.001}
* This models 60dB PSRR (1/1000).

E_ldo n3v3_ideal 0 VALUE = {3.3 + V(5v_clean)*0.001}
R_out n3v3_ideal n3v3_out 0.1
C_out n3v3_out 0 10u

* Analysis
.ac dec 100 1k 10MEG

* Control Block
.control
run
* Plot Attenuation
* Vin AC = 1. Vout AC = v(n3v3_out).
* Attenuation dB = 20*log10(v(n3v3_out)/1)
let atten_db = db(v(n3v3_out))

* Measure attenuation at 1.1MHz
meas ac atten_1M1 FIND atten_db AT=1.1MEG

print atten_1M1
.endc
.end
