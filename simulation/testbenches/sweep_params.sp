.param VBUS=170
.param K=0.35
.param C_TOL=1.0
.param TAMB=25
.param FAN=1.0
.param T_POWERED=0.5
.param T_OBSERVE=0.1
