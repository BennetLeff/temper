* Full-Wave Voltage Doubler Rectifier
* sim_33_voltage_doubler.cir
*
* PURPOSE: Verify voltage doubler rectifier for 120VAC → 340VDC
*          to enable 1800W operation on 15A outlet.
*
* TOPOLOGY: Full-Wave (Delon) Voltage Doubler
*
*                    D1 →
*     Line o────┬────>|────┬───── +Vbus/2 (node: bus_p)
*               │          │
*               │         C1
*              (~)       2200µF
*              AC          │
*               │          ├───── GND (center tap)
*               │          │
*               │         C2
*               │        2200µF
*               │          │
*     Neutral o─┴────|<────┴───── -Vbus/2 (node: bus_n)
*                    D2 ←
*
* Total output: V(bus_p) - V(bus_n) = 2×Vpeak = 340V
*
* Advantages over half-wave:
* - Full-wave ripple frequency (120Hz vs 60Hz)
* - Better regulation under load
* - Lower ripple for same capacitance
*
***************************************************************************

.title Full-Wave Voltage Doubler for 120VAC Induction Cooker

***************************************************************************
* PARAMETERS
***************************************************************************
.param VAC=120              ; RMS input voltage
.param FREQ=60              ; Mains frequency
.param VPEAK={VAC*sqrt(2)}  ; Peak voltage = 170V

* Load for 1800W at 340V: P=V²/R → R=340²/1800 = 64Ω
.param R_LOAD=64

* Capacitor size for acceptable ripple
* Full-wave: f_ripple = 120Hz, so caps can be smaller
* Increased to 3300uF for better regulation at 1800W
.param C_RAIL=3300u

***************************************************************************
* CONVERGENCE AIDS
***************************************************************************
.options reltol=1e-3
.options abstol=1e-9
.options vntol=1e-4
.options gmin=1e-10
.options itl1=500
.options itl4=100

***************************************************************************
* AC SOURCE
***************************************************************************
V_ac line neutral SIN(0 {VPEAK} {FREQ})

* Ground reference at neutral
R_neutral neutral 0 0.001

* Small source impedance
R_src line line_in 0.05

***************************************************************************
* FULL-WAVE VOLTAGE DOUBLER
***************************************************************************
* On positive half-cycle: D1 conducts, charges C1, bus_p goes to +Vpeak
* On negative half-cycle: D2 conducts, charges C2, bus_n goes to -Vpeak
* Total output = bus_p - bus_n = 2 × Vpeak

* D1: Upper diode (conducts when line is positive)
D1 line_in bus_p DIODE_FAST

* D2: Lower diode (conducts when line is negative)
D2 bus_n line_in DIODE_FAST

* C1: Upper capacitor (bus_p to center)
C1 bus_p 0 {C_RAIL} IC={VPEAK}

* C2: Lower capacitor (center to bus_n)
C2 0 bus_n {C_RAIL} IC={VPEAK}

* Load across full output (bus_p to bus_n)
R_load bus_p bus_n {R_LOAD}

* Bleeder resistors (balanced)
R_bleed1 bus_p 0 100k
R_bleed2 0 bus_n 100k

***************************************************************************
* DIODE MODEL - MUR1560 (15A, 600V ultrafast)
***************************************************************************
.model DIODE_FAST D(IS=1e-9 RS=0.012 N=1.7 BV=600 IBV=1e-6 CJO=150p TT=35n)

***************************************************************************
* ANALYSIS
***************************************************************************
.tran 20u 500m 0 20u uic

***************************************************************************
* CONTROL SCRIPT
***************************************************************************
.control
run

echo ""
echo "============================================================"
echo "FULL-WAVE VOLTAGE DOUBLER - Simulation 33"
echo "============================================================"
echo ""
echo "INPUT:"
echo "  AC Voltage: 120V RMS (170V peak)"
echo "  Frequency: 60 Hz"
echo ""
echo "TOPOLOGY: Full-Wave (Delon) Voltage Doubler"
echo "  - C1, C2: 2200uF each (split rail)"
echo "  - D1, D2: MUR1560 (15A, 600V ultrafast)"
echo "  - Output: +/-170V rails (340V total)"
echo ""
echo "LOAD:"
echo "  Resistance: 64 ohm"
echo "  Target power: 1800W at 340V"
echo ""

* Calculate total bus voltage
let vbus = v(bus_p) - v(bus_n)

* Measure steady state (last 100ms)
meas tran V_bus_avg avg vbus from=400m to=500m
meas tran V_bus_min min vbus from=400m to=500m
meas tran V_bus_max max vbus from=400m to=500m
meas tran V_ripple pp vbus from=400m to=500m

* Measure individual rails
meas tran V_pos_avg avg v(bus_p) from=400m to=500m
meas tran V_neg_avg avg v(bus_n) from=400m to=500m

echo ""
echo "============================================================"
echo "RAIL VOLTAGES (steady state)"
echo "============================================================"
echo ""
echo "+Rail (bus_p):       " $&V_pos_avg "V"
echo "-Rail (bus_n):       " $&V_neg_avg "V"
echo ""

echo "============================================================"
echo "TOTAL BUS VOLTAGE"
echo "============================================================"
echo ""
echo "V_bus (average):     " $&V_bus_avg "V"
echo "V_bus (minimum):     " $&V_bus_min "V"
echo "V_bus (maximum):     " $&V_bus_max "V"
echo "V_ripple (pk-pk):    " $&V_ripple "V"
echo ""

* Calculate power delivered
let P_load = V_bus_avg * V_bus_avg / 64
let I_load = V_bus_avg / 64

echo "============================================================"
echo "POWER DELIVERY"
echo "============================================================"
echo ""
echo "Load current:        " $&I_load "A (total through load)"
echo "Load power:          " $&P_load "W"
echo ""

echo "============================================================"
echo "VERIFICATION RESULTS"
echo "============================================================"
echo ""

* DC bus voltage check
echo "REQUIREMENT: DC bus >= 300V for 1500W+ operation"
if V_bus_avg >= 300
    echo "  DC BUS VOLTAGE:    PASS (" $&V_bus_avg "V >= 300V)"
else
    if V_bus_avg >= 270
        echo "  DC BUS VOLTAGE:    MARGINAL (" $&V_bus_avg "V, 270-300V)"
    else
        echo "  DC BUS VOLTAGE:    FAIL (" $&V_bus_avg "V < 270V)"
    end
end
echo ""

* Ripple check
echo "REQUIREMENT: Ripple < 30V (9% of 340V)"
if V_ripple < 30
    echo "  RIPPLE VOLTAGE:    PASS (" $&V_ripple "V < 30V)"
else
    if V_ripple < 50
        echo "  RIPPLE VOLTAGE:    ACCEPTABLE (" $&V_ripple "V, 30-50V)"
    else
        echo "  RIPPLE VOLTAGE:    WARN (" $&V_ripple "V >= 50V)"
    end
end
echo ""

* Power delivery check
echo "REQUIREMENT: Load power >= 1500W"
if P_load >= 1500
    echo "  POWER DELIVERY:    PASS (" $&P_load "W >= 1500W)"
else
    if P_load >= 1200
        echo "  POWER DELIVERY:    MARGINAL (" $&P_load "W, 1200-1500W)"
    else
        echo "  POWER DELIVERY:    FAIL (" $&P_load "W < 1200W)"
    end
end
echo ""

echo "============================================================"
echo "COMPONENT SPECIFICATIONS"
echo "============================================================"
echo ""
echo "CAPACITORS (C1, C2):"
echo "  Value:             3300uF (3.3mF) each"
echo "  Voltage rating:    250V minimum each (split rail)"
echo "  Type:              Electrolytic, 105°C, low ESR"
echo "  Ripple current:    High ripple rating required (>5A RMS)"
echo "  Note:              Each cap sees only Vpeak = 170V"
echo ""
echo "DIODES (D1, D2):"
echo "  Part:              MUR1560 or equivalent"
echo "  Current:           15A average, 50A surge"
echo "  Voltage:           600V PIV (sees 2×Vpeak during reverse)"
echo "  Recovery:          <50ns ultrafast"
echo ""
echo "COMPARISON TO HALF-WAVE:"
echo "  + Lower ripple (120Hz vs 60Hz)"
echo "  + Better regulation under load"
echo "  + Balanced capacitor stress"
echo "  - Requires center-referenced load (split supply)"
echo ""

quit
.endc

.end
