* Full Power Stage Simulation - Half-Bridge + Resonant Tank
* sim_26_full_power_stage.cir
*
* PURPOSE: Complete system-level simulation of the induction cooker
*          power stage including:
*          - AC rectifier input
*          - Half-bridge IGBTs with gate drivers
*          - Resonant LC tank
*          - Pan load model
*
* This is the integration simulation that validates the complete
* power conversion chain at target operating conditions.
*
* TARGET SPECIFICATIONS:
*   - Input: 230VAC, 50Hz
*   - DC Bus: 320V
*   - Output Power: 2kW (adjustable via frequency)
*   - Switching Frequency: 35-50kHz
*   - Efficiency Target: >90% (>95% with ZVS)
*
***************************************************************************

.title Full Power Stage - Half-Bridge + Resonant Tank Integration

***************************************************************************
* CONVERGENCE OPTIONS
***************************************************************************
.options reltol=1e-3
.options abstol=1e-9
.options vntol=1e-4
.options gmin=1e-10
.options method=gear
.options maxord=2
.options itl1=500
.options itl2=200
.options itl4=100

***************************************************************************
* INCLUDE MODELS
***************************************************************************
.include ../models/IKW40N120H3.lib
.include ../models/pan_load.sub

***************************************************************************
* SIMULATION PARAMETERS
***************************************************************************
* Power stage operating point
.param VDC=320               ; DC bus voltage (from rectified mains)
.param F_SW=38k              ; Switching frequency (above resonance)
.param PERIOD={1/F_SW}       ; Switching period
.param DUTY=0.47             ; Duty cycle per switch
.param T_ON={PERIOD*DUTY}
.param DT_NS=500             ; Dead-time in ns
.param DT={DT_NS*1n}

* Gate drive parameters
.param VGE_ON=15
.param RG=5

* Resonant tank parameters
.param C_RES=330n            ; Resonant capacitor
.param L1=80u                ; Coil inductance (uncoupled)
.param K_COUPLE=0.5          ; Pan coupling coefficient
.param L_EFF={L1*(1-K_COUPLE*K_COUPLE)}  ; ~60uH effective
.param R_PAN=8               ; Cast iron reflected resistance
.param R_COIL=0.1            ; Coil AC resistance

***************************************************************************
* DC BUS (Pre-charged for simulation speed)
* In real system: comes from bridge rectifier with PFC
***************************************************************************
* Main DC bus (soft-start)
V_dcbus vbus 0 PWL(0 0 50u {VDC} 1m {VDC})

* Bus capacitors (typical: 470uF electrolytic + 1uF film)
C_bus1 vbus 0 470u IC=0
C_film vbus 0 1u

* Virtual midpoint for resonant tank return
* In real circuit, this could be:
* 1. Actual split bus capacitors, or
* 2. Resonant tank returns to low-side emitter (quasi-resonant)
R_mid_upper vbus vmid 1MEG
R_mid_lower vmid 0 1MEG
C_mid_upper vbus vmid 100u IC={VDC/2}
C_mid_lower vmid 0 100u IC={VDC/2}

***************************************************************************
* GATE DRIVER SUPPLIES
* In real system: from isolated DC-DC (UCC14240-Q1)
***************************************************************************
V_vdd_hi vdd_hi gnd_hi DC {VGE_ON}
V_vdd_lo vdd_lo 0 DC {VGE_ON}

***************************************************************************
* PWM GATE DRIVE SIGNALS
* In real system: from ESP32 via UCC21550
***************************************************************************
* High-side gate (Q1)
V_pwm_hi gate_hi_in gnd_hi PWL(
+ 0 0
+ {DT/2} 0
+ {DT/2 + 10n} {VGE_ON}
+ {T_ON - 10n} {VGE_ON}
+ {T_ON} 0
+ {PERIOD} 0
+ {PERIOD + DT/2} 0
+ {PERIOD + DT/2 + 10n} {VGE_ON}
+ {PERIOD + T_ON - 10n} {VGE_ON}
+ {PERIOD + T_ON} 0
+ {2*PERIOD} 0
+ {2*PERIOD + DT/2} 0
+ {2*PERIOD + DT/2 + 10n} {VGE_ON}
+ {2*PERIOD + T_ON - 10n} {VGE_ON}
+ {2*PERIOD + T_ON} 0
+ {3*PERIOD} 0
+ {3*PERIOD + DT/2} 0
+ {3*PERIOD + DT/2 + 10n} {VGE_ON}
+ {3*PERIOD + T_ON - 10n} {VGE_ON}
+ {3*PERIOD + T_ON} 0
+ {4*PERIOD} 0
+ {4*PERIOD + DT/2} 0
+ {4*PERIOD + DT/2 + 10n} {VGE_ON}
+ {4*PERIOD + T_ON - 10n} {VGE_ON}
+ {4*PERIOD + T_ON} 0
+ {5*PERIOD} 0
+ {5*PERIOD + DT/2} 0
+ {5*PERIOD + DT/2 + 10n} {VGE_ON}
+ {5*PERIOD + T_ON - 10n} {VGE_ON}
+ {5*PERIOD + T_ON} 0
+ {6*PERIOD} 0
+ {6*PERIOD + DT/2} 0
+ {6*PERIOD + DT/2 + 10n} {VGE_ON}
+ {6*PERIOD + T_ON - 10n} {VGE_ON}
+ {6*PERIOD + T_ON} 0
+ {7*PERIOD} 0
+ {7*PERIOD + DT/2} 0
+ {7*PERIOD + DT/2 + 10n} {VGE_ON}
+ {7*PERIOD + T_ON - 10n} {VGE_ON}
+ {7*PERIOD + T_ON} 0
+ {8*PERIOD} 0
+ {8*PERIOD + DT/2} 0
+ {8*PERIOD + DT/2 + 10n} {VGE_ON}
+ {8*PERIOD + T_ON - 10n} {VGE_ON}
+ {8*PERIOD + T_ON} 0
+ 1m 0)

R_gate_hi gate_hi_in gate_hi {RG}

* Low-side gate (Q2) - Complementary
V_pwm_lo gate_lo_in 0 PWL(
+ 0 0
+ {T_ON + DT} 0
+ {T_ON + DT + 10n} {VGE_ON}
+ {PERIOD - 10n} {VGE_ON}
+ {PERIOD} 0
+ {PERIOD + T_ON + DT} 0
+ {PERIOD + T_ON + DT + 10n} {VGE_ON}
+ {2*PERIOD - 10n} {VGE_ON}
+ {2*PERIOD} 0
+ {2*PERIOD + T_ON + DT} 0
+ {2*PERIOD + T_ON + DT + 10n} {VGE_ON}
+ {3*PERIOD - 10n} {VGE_ON}
+ {3*PERIOD} 0
+ {3*PERIOD + T_ON + DT} 0
+ {3*PERIOD + T_ON + DT + 10n} {VGE_ON}
+ {4*PERIOD - 10n} {VGE_ON}
+ {4*PERIOD} 0
+ {4*PERIOD + T_ON + DT} 0
+ {4*PERIOD + T_ON + DT + 10n} {VGE_ON}
+ {5*PERIOD - 10n} {VGE_ON}
+ {5*PERIOD} 0
+ {5*PERIOD + T_ON + DT} 0
+ {5*PERIOD + T_ON + DT + 10n} {VGE_ON}
+ {6*PERIOD - 10n} {VGE_ON}
+ {6*PERIOD} 0
+ {6*PERIOD + T_ON + DT} 0
+ {6*PERIOD + T_ON + DT + 10n} {VGE_ON}
+ {7*PERIOD - 10n} {VGE_ON}
+ {7*PERIOD} 0
+ {7*PERIOD + T_ON + DT} 0
+ {7*PERIOD + T_ON + DT + 10n} {VGE_ON}
+ {8*PERIOD - 10n} {VGE_ON}
+ {8*PERIOD} 0
+ 1m {VGE_ON})

R_gate_lo gate_lo_in gate_lo {RG}

***************************************************************************
* HALF-BRIDGE POWER STAGE
***************************************************************************
* High-side IGBT (Q1)
X_Q1 vbus gate_hi midpoint IKW40N120H3

* High-side gate reference
V_gnd_hi_ref gnd_hi midpoint DC 0

* Low-side IGBT (Q2)
X_Q2 midpoint gate_lo emit_lo IKW40N120H3

* Current sense resistor (for measurement)
R_sense emit_lo 0 1m

***************************************************************************
* RC SNUBBERS (optional, may not be needed with ZVS)
***************************************************************************
* Snubbers help with hard-switching but can be omitted with ZVS
* Uncomment if needed:
* C_snub_hi midpoint vbus 10n
* R_snub_hi midpoint n_snub_hi 10
* V_snub_hi n_snub_hi vbus DC 0

* C_snub_lo 0 midpoint 10n
* R_snub_lo 0 n_snub_lo 10
* V_snub_lo n_snub_lo midpoint DC 0

***************************************************************************
* RESONANT TANK
***************************************************************************
* Series LC resonant tank connected from half-bridge midpoint
* to virtual bus midpoint (or returns to low-side in quasi-resonant)

* Resonant capacitor (high-voltage, low-ESR film type)
* Typical: polypropylene film, 630V rating
C_res midpoint n_cap {C_RES} IC=0

* Small ESR of resonant capacitor (film caps have very low ESR)
R_cap_esr n_cap n_cap2 0.01

* Induction coil with pan loading
* Using effective inductance model (simplified)
L_coil n_cap2 n_l {L_EFF} IC=0

* Coil AC resistance (includes skin effect, proximity losses)
R_coil n_l n_r {R_COIL}

* Reflected pan resistance (this is where power is delivered!)
R_pan n_r vmid {R_PAN}

***************************************************************************
* CURRENT MEASUREMENT (for current sensing and OCP)
***************************************************************************
* The inductor current can be sensed for:
* 1. Over-current protection
* 2. Pan detection (current level indicates loading)
* 3. ZVS verification (current direction at switching)
V_i_sense n_l n_l_sense DC 0
R_i_dummy n_l_sense n_r 0

* Alternative: Current transformer on tank
* (see current_transformer.sub for detailed model)

***************************************************************************
* ANALYSIS
***************************************************************************
* Run for multiple switching cycles to reach steady state
.tran 5n 400u 0 5n uic

* Initial conditions
.ic V(vbus)=0
.ic V(midpoint)=0
.ic V(n_cap)=0

***************************************************************************
* MEASUREMENTS
***************************************************************************
* Analysis window (skip startup)
.param T_START=200u
.param T_END=380u

* --- VOLTAGE MEASUREMENTS ---
.meas tran V_mid_max MAX v(midpoint) FROM={T_START} TO={T_END}
.meas tran V_mid_min MIN v(midpoint) FROM={T_START} TO={T_END}
.meas tran V_cap_max MAX v(n_cap) FROM={T_START} TO={T_END}
.meas tran V_bus_avg AVG v(vbus) FROM={T_START} TO={T_END}

* --- CURRENT MEASUREMENTS ---
.meas tran I_tank_max MAX i(L_coil) FROM={T_START} TO={T_END}
.meas tran I_tank_min MIN i(L_coil) FROM={T_START} TO={T_END}
.meas tran I_tank_rms RMS i(L_coil) FROM={T_START} TO={T_END}

***************************************************************************
* CONTROL SCRIPT
***************************************************************************
.control
run

echo ""
echo "============================================================"
echo "Full Power Stage Integration - Simulation 26"
echo "============================================================"
echo ""

echo "SYSTEM CONFIGURATION:"
echo "  DC Bus Voltage: 320V"
echo "  Switching Frequency: 38 kHz"
echo "  Resonant Frequency: ~35.8 kHz"
echo "  Duty Cycle: 47% per switch"
echo "  Dead-Time: 500 ns"
echo "  Resonant Capacitor: 330 nF"
echo "  Effective Inductance: 60 uH"
echo "  Reflected Resistance: 8 ohm (cast iron pan)"
echo ""

echo "============================================================"
echo "MEASUREMENT RESULTS (see above for values)"
echo "============================================================"
echo ""
echo "V_mid_max: Midpoint max voltage (should be ~320V)"
echo "V_mid_min: Midpoint min voltage (should be ~0V)"
echo "V_cap_max: Resonant capacitor peak voltage"
echo "V_bus_avg: Average DC bus voltage"
echo "I_tank_max/min: Peak tank current (+/-)"
echo "I_tank_rms: RMS current for power calc"
echo ""

echo "============================================================"
echo "POWER CALCULATION"
echo "============================================================"
echo ""
echo "Power to pan = I_rms^2 * R_pan (8 ohm)"
echo "Example calculations:"
echo "  At 15A RMS: P = 15^2 * 8 = 1800W"
echo "  At 20A RMS: P = 20^2 * 8 = 3200W"
echo ""

echo "============================================================"
echo "THERMAL CONSIDERATIONS"
echo "============================================================"
echo ""
echo "Loss breakdown (estimated for ~2kW output):"
echo "  IGBT conduction: ~15W each"
echo "  IGBT switching: ~5-10W each with ZVS"
echo "  Diode recovery: ~5W each with ZVS"
echo "  Coil resistance: I^2*R_coil"
echo "  Cap ESR: negligible"
echo "  Total estimated: ~50-80W (>95% efficiency)"
echo ""

echo "============================================================"
echo "OPERATING POINT SUMMARY"
echo "============================================================"
echo ""
echo "This simulation validates the complete power stage"
echo "operating above resonance for ZVS operation."
echo ""
echo "Power control strategy:"
echo "  - Higher frequency = less power"
echo "  - Lower frequency (toward resonance) = more power"
echo "  - Range: 35-55 kHz for 200W to 2.5kW"
echo ""

quit
.endc

.end
