* Induction Coil Thermal Loss Simulation
* sim_31_coil_thermal.cir
*
* PURPOSE: Calculate thermal losses in the induction coil at 2kW output
*          to determine cooling requirements.
*
* COIL DESIGN ASSUMPTIONS (typical 2kW induction cooker):
*   - Coil diameter: ~180mm (for hot-plate form factor)
*   - Turns: 20-25 turns, spiral planar coil
*   - Wire: Litz wire, 100-200 strands of AWG 38
*   - DC resistance: 20-50 mΩ (varies with wire gauge/length)
*   - AC resistance: 2-4x DC at 38kHz (skin/proximity effects)
*
* LOSS MECHANISMS:
*   1. I²R_dc - DC resistance losses
*   2. I²R_ac - AC resistance (skin effect, proximity effect)
*   3. Eddy currents in nearby conductors (minimal with proper design)
*
* For Litz wire at 38kHz, AC/DC resistance ratio ≈ 1.5-2.0
* (Litz wire specifically designed to minimize skin effect)
*
***************************************************************************

.title Induction Coil Thermal Loss Analysis

***************************************************************************
* SIMULATION PARAMETERS
***************************************************************************
* Operating point (120V/170Vdc system at 2kW)
.param VDC=170              ; DC bus from rectified 120VAC
.param F_SW=38k             ; Switching frequency
.param P_TARGET=2000        ; Target output power (W)
.param R_PAN=8              ; Cast iron pan reflected resistance

* Coil parameters (realistic values for 180mm diameter Litz coil)
.param L_COIL=80u           ; Coil inductance (uncoupled)
.param K_COUPLE=0.5         ; Pan coupling
.param L_EFF={L_COIL*(1-K_COUPLE*K_COUPLE)}  ; ~60uH effective

* Coil resistance - KEY THERMAL PARAMETERS
* DC resistance of ~5m Litz wire at 0.02 ohm/m = 0.1 ohm
.param R_DC=0.10            ; DC resistance at 25°C
.param R_AC_RATIO=1.8       ; AC/DC ratio at 38kHz for Litz
.param R_COIL_25C={R_DC*R_AC_RATIO}  ; AC resistance at 25°C = 0.18 ohm
.param TEMP_COEFF=0.00393   ; Copper temperature coefficient
.param T_COIL=80            ; Assumed coil operating temperature (°C)
.param R_COIL={R_COIL_25C*(1+TEMP_COEFF*(T_COIL-25))}  ; R at operating temp

* Resonant tank
.param C_RES=330n           ; Resonant capacitor
.param PERIOD={1/F_SW}
.param DUTY=0.47

***************************************************************************
* CALCULATE EXPECTED CURRENT
***************************************************************************
* At 2kW into 8 ohm pan:
* P = I_rms² × R_pan
* I_rms = sqrt(2000/8) = 15.8A RMS
* I_peak = 15.8 × sqrt(2) = 22.4A peak
*
* With 170V bus (vs 320V), current is actually higher relative to
* voltage, so power control works differently.
* Let's simulate and measure actual values.

***************************************************************************
* CIRCUIT
***************************************************************************

* DC Bus (pre-charged, 120V system)
V_bus vbus 0 DC {VDC}
C_bus vbus 0 470u IC={VDC}

* Split bus for resonant return
R_mid1 vbus vmid 100k
R_mid2 vmid 0 100k
C_mid1 vbus vmid 100u IC={VDC/2}
C_mid2 vmid 0 100u IC={VDC/2}

* Simplified half-bridge as square wave source
* (Using behavioral source to focus on coil losses)
V_bridge midpoint vmid PULSE({-VDC/2} {VDC/2} 0 10n 10n {DUTY*PERIOD} {PERIOD})

* Resonant capacitor
C_res midpoint n_cap {C_RES} IC=0
R_cap_esr n_cap n_cap2 0.01

* INDUCTION COIL - Main component under analysis
L_coil n_cap2 n_l {L_EFF} IC=0

* Coil resistance (temperature-adjusted)
* This is where the heat is generated!
R_coil n_l n_r {R_COIL}

* Pan reflected resistance (power sink)
R_pan n_r vmid {R_PAN}

***************************************************************************
* ANALYSIS
***************************************************************************
.tran 1u 2m 0 1u uic

* Steady-state window (skip startup)
.param T_START=1m
.param T_END=2m

* Current measurements
.meas tran I_coil_rms RMS i(L_coil) FROM={T_START} TO={T_END}
.meas tran I_coil_peak MAX i(L_coil) FROM={T_START} TO={T_END}
.meas tran I_coil_min MIN i(L_coil) FROM={T_START} TO={T_END}

* Voltage measurements
.meas tran V_cap_peak MAX v(n_cap) FROM={T_START} TO={T_END}
.meas tran V_bus_avg AVG v(vbus) FROM={T_START} TO={T_END}

* Power will be calculated in control script from I_rms

***************************************************************************
* CONTROL SCRIPT
***************************************************************************
.control
set wr_vecnames
set wr_singlescale

run

* Calculate RMS current from waveform
let i_coil = i(l_coil)
meas tran i_rms_calc RMS i_coil from=1m to=2m
meas tran i_peak_calc MAX i_coil from=1m to=2m

* Calculate power losses
let r_coil_val = 0.22
let r_pan_val = 8
let p_coil = i_rms_calc * i_rms_calc * r_coil_val
let p_pan = i_rms_calc * i_rms_calc * r_pan_val
let efficiency = p_pan / (p_pan + p_coil) * 100

echo ""
echo "============================================================"
echo "COIL THERMAL LOSS ANALYSIS - Simulation 31"
echo "============================================================"
echo ""

echo "SYSTEM CONFIGURATION:"
echo "  DC Bus Voltage: 170V (120VAC rectified)"
echo "  Switching Frequency: 38 kHz"
echo "  Target Power: 2 kW"
echo "  Pan Resistance: 8 ohm (cast iron)"
echo ""

echo "COIL PARAMETERS:"
echo "  Inductance (effective): 60 uH"
echo "  DC Resistance: 0.10 ohm"
echo "  AC/DC Ratio: 1.8 (Litz wire at 38kHz)"
echo "  AC Resistance (25C): 0.18 ohm"
echo "  AC Resistance (80C): 0.22 ohm (temp adjusted)"
echo ""

echo "============================================================"
echo "MEASURED RESULTS"
echo "============================================================"
print i_rms_calc
print i_peak_calc
print p_coil
print p_pan
print efficiency
echo ""

echo "============================================================"
echo "THERMAL ANALYSIS"
echo "============================================================"
echo ""
echo "Coil power loss (W):"
print p_coil
echo ""
echo "Power to pan (W):"
print p_pan
echo ""
echo "Coil efficiency (%):"
print efficiency
echo ""

echo "============================================================"
echo "COIL COOLING ASSESSMENT"
echo "============================================================"
echo ""
echo "For natural convection cooling:"
echo "  Coil thermal resistance ~2-4 K/W (exposed planar coil)"
echo "  Temperature rise = P_loss * Rth"
echo ""
echo "Example:"
echo "  If P_coil = 10W, Rth = 3 K/W"
echo "  Delta_T = 30C above ambient"
echo "  At 40C ambient -> Tcoil = 70C (acceptable)"
echo ""
echo "  If P_coil = 20W, Rth = 3 K/W"
echo "  Delta_T = 60C above ambient"
echo "  At 40C ambient -> Tcoil = 100C (needs airflow!)"
echo ""

echo "============================================================"
echo "RECOMMENDATIONS"
echo "============================================================"
echo ""
echo "If P_coil_loss < 10W:"
echo "  -> Natural convection OK, no dedicated cooling needed"
echo ""
echo "If P_coil_loss 10-20W:"
echo "  -> Shared airflow from IGBT heatsink fan recommended"
echo ""
echo "If P_coil_loss > 20W:"
echo "  -> Dedicated cooling or larger Litz wire needed"
echo ""

quit
.endc

.end
