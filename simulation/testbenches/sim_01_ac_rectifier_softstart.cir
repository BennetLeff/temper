*****************************************************************************
* Test Circuit: AC Rectifier + Soft-Start
* Task: temper-ew8.1
* Purpose: Verify AC mains rectification with soft-start feeding LMR51430
******************************************************************************

.TITLE AC Rectifier + Soft-Start for Auxiliary Power Supply

.INCLUDE ../../components/LMR51420/test_files/LMR51430.lib
.INCLUDE common_options.spice

*------------------------------------------------------------------------------
* Circuit Definition
*------------------------------------------------------------------------------
* AC Mains Input (120VAC RMS, 60Hz)
VAC VAC_IN 0 SIN(0 170 60 0 0)

* Full Bridge Rectifier
D1 VAC_IN RECT_OUT DRECT
D2 0 RECT_OUT DRECT
D3 VAC_IN 0 DRECT
D4 0 VAC_IN DRECT
.MODEL DRECT D(IS=1E-14 RS=0.1 N=1.0 VJ=0.7)

* Auxiliary Transformer Step-Down (120VAC → 18VAC)
VSEC SEC_IN 0 SIN(0 25.5 60 0 0)
D5 SEC_IN VRECT DRECT
D6 0 VRECT DRECT
D7 SEC_IN 0 DRECT
D8 0 SEC_IN DRECT

* Bulk Capacitor
CBULK VRECT 0 1000U IC=0

* Soft-Start Circuit
BSOFTSTART VRECT VSOFTSTART I=V(VRECT,VSOFTSTART)/(10 - 9.9*(1-exp(-time/0.1)))

* Input decoupling for LMR51430
CIN_DECOUPLE VSOFTSTART 0 10U IC=0
RSENSE VSOFTSTART VIN_BUCK 0.01
REN VIN_BUCK EN 10K
CEN EN 0 10N IC=0

* LMR51430 Buck Converter
XU1 VIN_BUCK 0 EN SW FB CB LMR51430X
CBOOT CB SW 100N IC=0
L1 SW VOUT 6.8U IC=0
COUT VOUT 0 44U IC=0
RFBT VOUT FB 100K
RFBB FB 0 13.7K
RLOAD VOUT 0 4.17

*------------------------------------------------------------------------------
* Analysis
*------------------------------------------------------------------------------
.TRAN 10U 200M 0 10U UIC

*------------------------------------------------------------------------------
* Control Block for automated measurement
*------------------------------------------------------------------------------
.control
run
print vrect_dc vrect_ripple
print vin_buck_dc vin_buck_ripple
print vout_avg vout_ripple
print inrush_peak tstart
print

.endc

.END
