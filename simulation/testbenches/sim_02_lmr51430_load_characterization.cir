*******************************************************************************
* LMR51430 Buck Converter Load Characterization
* Task: temper-ew8.2
* Purpose: Verify LMR51430 performance across load range (100mA to 1.2A)
*          Test load regulation, transient response, ripple, and thermal
*******************************************************************************

.TITLE LMR51430 Load Characterization and Transient Response

.INCLUDE ../../components/LMR51420/test_files/LMR51430.lib

*------------------------------------------------------------------------------
* Options for stable simulation
*------------------------------------------------------------------------------
.OPTIONS RELTOL=0.001 ABSTOL=1N VNTOL=1M
.OPTIONS ITL1=300 ITL4=100
.OPTIONS METHOD=TRAP

*------------------------------------------------------------------------------
* Input Voltage Source (Test at 12V, 18V, and 24V)
* Start with 18V (nominal auxiliary supply voltage)
*------------------------------------------------------------------------------
VIN VIN 0 PWL(0 0 100U 18 100M 18)

*------------------------------------------------------------------------------
* Input Decoupling (per datasheet Section 8.2.2)
* 10uF ceramic X7R (minimum), 22uF recommended for low ESR
*------------------------------------------------------------------------------
CIN VIN VIN_ESR 22U IC=0
RESR_CIN VIN_ESR 0 5m

*------------------------------------------------------------------------------
* Enable Control (delay to allow input to settle)
*------------------------------------------------------------------------------
REN VIN EN 10K
CEN EN 0 10N IC=0

*------------------------------------------------------------------------------
* LMR51430 Buck Converter (500kHz variant)
*------------------------------------------------------------------------------
XU1 VIN 0 EN SW FB CB LMR51430X

*------------------------------------------------------------------------------
* Bootstrap Capacitor (per datasheet Section 8.2.2)
* 100nF ceramic X7R
*------------------------------------------------------------------------------
CBOOT CB SW 100N IC=0

*------------------------------------------------------------------------------
* Output Inductor (per datasheet calculation)
* L = 6.8uH for 500kHz, 18V→5V, 2A
* Using low DCR inductor (<50mΩ for efficiency)
*------------------------------------------------------------------------------
L1 SW SW_L 6.8U IC=0
RDCR_L1 SW_L VOUT 40m

*------------------------------------------------------------------------------
* Output Capacitor (per datasheet Section 8.2.2)
* Minimum 22uF, recommend 44uF (2x22uF) for low ripple
* X7R ceramic, low ESR (<10mΩ total)
*------------------------------------------------------------------------------
COUT1 VOUT VOUT_ESR1 22U IC=0
RESR_COUT1 VOUT_ESR1 0 5m
COUT2 VOUT VOUT_ESR2 22U IC=0
RESR_COUT2 VOUT_ESR2 0 5m

*------------------------------------------------------------------------------
* Feedback Divider for 5V output
* VOUT = 0.6V × (1 + RFBT/RFBB)
* For 5.0V: RFBB = 100k / (5/0.6 - 1) = 13.64k → use 13.7k (1% resistor)
*------------------------------------------------------------------------------
RFBT VOUT FB 100K
RFBB FB 0 13.7K

*------------------------------------------------------------------------------
* Load Profile (realistic current budget)
* Phase 1 (0-20ms): Light load 100mA (quiescent/idle)
* Phase 2 (20-40ms): Medium load 600mA (normal operation)
* Phase 3 (40-60ms): Heavy load 1.2A (peak, all peripherals + WiFi)
* Phase 4 (60-80ms): Back to medium 600mA
* Phase 5 (80-100ms): Back to light 100mA
*------------------------------------------------------------------------------
* Using PWL current source for load steps
ILOAD 0 VOUT PWL(
+ 0      0
+ 10M    0.1
+ 20M    0.1
+ 20.01M 0.6
+ 40M    0.6
+ 40.01M 1.2
+ 60M    1.2
+ 60.01M 0.6
+ 80M    0.6
+ 80.01M 0.1
+ 100M   0.1
+ )

*------------------------------------------------------------------------------
* Analysis
* Run for 100ms to capture all load transitions
* Use fine timestep (100ns) to capture switching ripple accurately
*------------------------------------------------------------------------------
.TRAN 100N 100M 0 100N UIC

*------------------------------------------------------------------------------
* Measurements - Load Regulation
*------------------------------------------------------------------------------
* Light load (100mA)
.MEAS TRAN VOUT_LIGHT AVG V(VOUT) FROM=15M TO=20M
.MEAS TRAN RIPPLE_LIGHT PP V(VOUT) FROM=18M TO=19M

* Medium load (600mA)
.MEAS TRAN VOUT_MEDIUM AVG V(VOUT) FROM=25M TO=30M
.MEAS TRAN RIPPLE_MEDIUM PP V(VOUT) FROM=28M TO=29M

* Heavy load (1.2A)
.MEAS TRAN VOUT_HEAVY AVG V(VOUT) FROM=50M TO=60M
.MEAS TRAN RIPPLE_HEAVY PP V(VOUT) FROM=55M TO=56M

*------------------------------------------------------------------------------
* Measurements - Load Transient Response
*------------------------------------------------------------------------------
* Step 1: 100mA → 600mA (at 20ms)
.MEAS TRAN VOUT_BEFORE_STEP1 AVG V(VOUT) FROM=19M TO=19.99M
.MEAS TRAN VDROP_STEP1 MIN V(VOUT) FROM=20M TO=21M
.MEAS TRAN RECOVERY_STEP1 WHEN V(VOUT)=4.95 RISE=1 TD=20M

* Step 2: 600mA → 1.2A (at 40ms)
.MEAS TRAN VOUT_BEFORE_STEP2 AVG V(VOUT) FROM=39M TO=39.99M
.MEAS TRAN VDROP_STEP2 MIN V(VOUT) FROM=40M TO=41M
.MEAS TRAN RECOVERY_STEP2 WHEN V(VOUT)=4.95 RISE=1 TD=40M

* Step 3: 1.2A → 600mA (at 60ms) - load release
.MEAS TRAN VOUT_BEFORE_STEP3 AVG V(VOUT) FROM=59M TO=59.99M
.MEAS TRAN VOVERSHOOT_STEP3 MAX V(VOUT) FROM=60M TO=61M
.MEAS TRAN RECOVERY_STEP3 WHEN V(VOUT)=5.05 FALL=1 TD=60M

*------------------------------------------------------------------------------
* Measurements - Input Current (for thermal calc)
*------------------------------------------------------------------------------
.MEAS TRAN IIN_LIGHT AVG I(VIN) FROM=15M TO=20M
.MEAS TRAN IIN_MEDIUM AVG I(VIN) FROM=25M TO=30M
.MEAS TRAN IIN_HEAVY AVG I(VIN) FROM=50M TO=60M

*------------------------------------------------------------------------------
* Measurements - Switching Frequency Verification
*------------------------------------------------------------------------------
.MEAS TRAN FSW_PERIOD TRIG V(SW) VAL=9 RISE=1 TD=50M TARG V(SW) VAL=9 RISE=2 TD=50M

*------------------------------------------------------------------------------
* Control Script
*------------------------------------------------------------------------------
.CONTROL

set filetype=ascii
set color0=white
set color1=red
set color2=blue
set color3=green
set color4=magenta
set color5=cyan

echo ""
echo "============================================================"
echo "  LMR51430 Buck Converter Load Characterization"
echo "  Task: temper-ew8.2"
echo "============================================================"
echo ""

run

echo ""
echo "Simulation complete! Processing results..."
echo ""

* Calculate derived parameters
let iload_100ma = 0.1
let iload_600ma = 0.6
let iload_1200ma = 1.2

* Load regulation error
let regulation_error_med = abs((vout_medium - vout_light)/vout_light)*100
let regulation_error_heavy = abs((vout_heavy - vout_light)/vout_light)*100

* Transient response calculations
let undershoot_step1 = vout_before_step1 - vdrop_step1
let undershoot_step2 = vout_before_step2 - vdrop_step2
let overshoot_step3 = vovershoot_step3 - vout_before_step3

* Efficiency estimates (simplified)
let eff_light = (vout_light * iload_100ma) / (18 * iin_light) * 100
let eff_medium = (vout_medium * iload_600ma) / (18 * iin_medium) * 100
let eff_heavy = (vout_heavy * iload_1200ma) / (18 * iin_heavy) * 100

* Power dissipation (for thermal calculation)
let pdiss_light = 18*iin_light - vout_light*iload_100ma
let pdiss_medium = 18*iin_medium - vout_medium*iload_600ma
let pdiss_heavy = 18*iin_heavy - vout_heavy*iload_1200ma

* Junction temperature (assuming θJA = 80°C/W, TA = 70°C worst-case)
let theta_ja = 80
let t_ambient = 70
let tj_light = t_ambient + pdiss_light * theta_ja
let tj_medium = t_ambient + pdiss_medium * theta_ja
let tj_heavy = t_ambient + pdiss_heavy * theta_ja

* Switching frequency
let fsw_khz = 1/(fsw_period*1e-3)

echo ""
echo "============================================================"
echo "LOAD REGULATION RESULTS:"
echo "============================================================"
print vout_light vout_medium vout_heavy
print ripple_light ripple_medium ripple_heavy
echo ""
echo "Regulation Error (vs light load):"
print regulation_error_med regulation_error_heavy
echo ""

echo "============================================================"
echo "LOAD TRANSIENT RESPONSE:"
echo "============================================================"
echo "Step 1: 100mA → 600mA (500mA step)"
print vout_before_step1 vdrop_step1 undershoot_step1
echo ""
echo "Step 2: 600mA → 1.2A (600mA step)"
print vout_before_step2 vdrop_step2 undershoot_step2
echo ""
echo "Step 3: 1.2A → 600mA (load release)"
print vout_before_step3 vovershoot_step3 overshoot_step3
echo ""

echo "============================================================"
echo "THERMAL PERFORMANCE:"
echo "============================================================"
print iin_light iin_medium iin_heavy
print pdiss_light pdiss_medium pdiss_heavy
print tj_light tj_medium tj_heavy
echo ""

echo "============================================================"
echo "EFFICIENCY ESTIMATES:"
echo "============================================================"
print eff_light eff_medium eff_heavy
echo ""

echo "============================================================"
echo "SWITCHING FREQUENCY:"
echo "============================================================"
print fsw_period fsw_khz
echo ""

echo "============================================================"
echo "VERIFICATION CRITERIA:"
echo "============================================================"
echo "✓ Output voltage regulation: ±2% (4.90V to 5.10V)"
echo "✓ Switching ripple: <50mV peak-to-peak"
echo "✓ Load transient undershoot: <5% (>4.75V)"
echo "✓ Load transient overshoot: <5% (<5.25V)"
echo "✓ Junction temperature: <150°C max (150°C limit)"
echo "✓ Switching frequency: 500kHz ± 10% (450-550kHz)"
echo "============================================================"
echo ""

* Automated verification checks
if vout_light > 4.90 & vout_light < 5.10
  echo "✓ PASS: Light load voltage in spec (4.90-5.10V)"
else
  echo "✗ FAIL: Light load voltage out of spec"
end

if vout_medium > 4.90 & vout_medium < 5.10
  echo "✓ PASS: Medium load voltage in spec (4.90-5.10V)"
else
  echo "✗ FAIL: Medium load voltage out of spec"
end

if vout_heavy > 4.90 & vout_heavy < 5.10
  echo "✓ PASS: Heavy load voltage in spec (4.90-5.10V)"
else
  echo "✗ FAIL: Heavy load voltage out of spec"
end

if ripple_heavy < 0.050
  echo "✓ PASS: Ripple at full load <50mV"
else
  echo "✗ FAIL: Ripple at full load >50mV"
end

if vdrop_step1 > 4.75
  echo "✓ PASS: Load transient Step1 undershoot <5%"
else
  echo "✗ FAIL: Load transient Step1 undershoot >5%"
end

if vdrop_step2 > 4.75
  echo "✓ PASS: Load transient Step2 undershoot <5%"
else
  echo "✗ FAIL: Load transient Step2 undershoot >5%"
end

if vovershoot_step3 < 5.25
  echo "✓ PASS: Load release overshoot <5%"
else
  echo "✗ FAIL: Load release overshoot >5%"
end

if tj_heavy < 150
  echo "✓ PASS: Junction temperature at full load <150°C"
else
  echo "✗ FAIL: Junction temperature at full load >150°C (THERMAL ISSUE!)"
end

if fsw_khz > 450 & fsw_khz < 550
  echo "✓ PASS: Switching frequency within ±10% of 500kHz"
else
  echo "✗ FAIL: Switching frequency out of spec"
end

echo ""
echo "Simulation results saved to: sim_02_lmr51430_load_characterization.raw"
echo ""

.ENDC

.END
