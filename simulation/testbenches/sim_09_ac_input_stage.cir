*******************************************************************************
* Lesson 09: AC Input Stage Design for Induction Cooker
* Task: temper-37v.9
* Purpose: Full-bridge rectifier + soft-start + EMI filter + protection
*          Design for 2kW induction cooker
*******************************************************************************

.TITLE Lesson 09: AC Input Stage Design (Full Bridge + Soft-Start)

*------------------------------------------------------------------------------
* Options for stable simulation
*------------------------------------------------------------------------------
.OPTIONS RELTOL=0.003 ABSTOL=1N VNTOL=1M
.OPTIONS ITL1=500 ITL4=200
.OPTIONS METHOD=GEAR MAXORD=2

*******************************************************************************
* DESIGN SPECIFICATIONS
*******************************************************************************
* Power: 2000W maximum
* Input: 240VAC, 50Hz (worst case for inrush)
* DC Bus: 320-340V DC (from 240VAC)
* Inrush Current: <20A peak
* Soft-start Time: 50-100ms
* Ripple: <50V p-p at full load
*******************************************************************************

*------------------------------------------------------------------------------
* AC MAINS INPUT (240VAC RMS, 50Hz)
* Peak voltage = 240V × √2 = 340V
*------------------------------------------------------------------------------
VAC N_LINE 0 SIN(0 340 50 0 0)

*------------------------------------------------------------------------------
* INPUT PROTECTION: FUSE (15A slow-blow)
*------------------------------------------------------------------------------
R_FUSE N_LINE N_FUSED 0.02

*------------------------------------------------------------------------------
* EMI FILTER (Simplified Differential Mode)
* L-C pi filter for differential mode noise
*------------------------------------------------------------------------------
L_EMI N_FUSED N_LESR 100u IC=0
R_LESR N_LESR N_FILT 0.1
C_X N_FILT 0 470n IC=0

*------------------------------------------------------------------------------
* FULL BRIDGE RECTIFIER (GBU8K equivalent)
*------------------------------------------------------------------------------
D1 N_FILT N_RECT_RAW DRECT
D2 0 N_RECT_RAW DRECT
D3 N_NEG N_FILT DRECT
D4 N_NEG 0 DRECT
.MODEL DRECT D(IS=1E-14 RS=0.02 N=1.0 VJ=0.7)

* Return path
R_RET N_NEG 0 0.001

*------------------------------------------------------------------------------
* SOFT-START: PRE-CHARGE RESISTOR
* I_inrush = V_peak / R = 340V / 22Ω = 15.5A < 20A ✓
*------------------------------------------------------------------------------
R_PRECHARGE N_RECT_RAW N_AFTER_PC 22

*------------------------------------------------------------------------------
* RELAY BYPASS (closes at t=100ms)
* Model as switch: R=1MEG open, R=0.01Ω closed
*------------------------------------------------------------------------------
* Using behavioral resistor with smooth transition
S_RELAY N_RECT_RAW N_AFTER_PC V_CTRL 0 SW_RELAY
V_CTRL N_CTRL 0 PWL(0 0 99m 0 100m 1 400m 1)
.MODEL SW_RELAY SW(RON=0.01 ROFF=1MEG VT=0.5 VH=0.1)

*------------------------------------------------------------------------------
* CURRENT SENSE (measure total rectifier current)
*------------------------------------------------------------------------------
V_ISENSE N_AFTER_PC DC_BUS 0

*------------------------------------------------------------------------------
* DC BUS BULK CAPACITORS (2200µF for lower ripple)
* For 2kW at 100Hz ripple: ΔV = I/(2×f×C) = 6.25A/(2×100×2200µF) = 14.2V
*------------------------------------------------------------------------------
C_BUS DC_BUS 0 2200u IC=0

*------------------------------------------------------------------------------
* LOAD (2kW at 320V → 51.2Ω)
* Switched on at t=150ms (after soft-start complete)
*------------------------------------------------------------------------------
R_LOAD_BASE DC_BUS 0 100k
S_LOAD DC_BUS N_LOAD V_LOAD 0 SW_LOAD
R_LOAD N_LOAD 0 51.2
V_LOAD N_LOAD_CTRL 0 PWL(0 0 149m 0 150m 1 400m 1)
.MODEL SW_LOAD SW(RON=0.01 ROFF=1MEG VT=0.5 VH=0.1)

*------------------------------------------------------------------------------
* ANALYSIS
*------------------------------------------------------------------------------
.TRAN 100U 400M 0 100U UIC

*------------------------------------------------------------------------------
* MEASUREMENTS
*------------------------------------------------------------------------------
.MEAS TRAN I_INRUSH_PEAK MAX I(V_ISENSE) FROM=0 TO=100M
.MEAS TRAN DC_BUS_AVG AVG V(DC_BUS) FROM=300M TO=400M
.MEAS TRAN DC_BUS_RIPPLE PP V(DC_BUS) FROM=350M TO=400M
.MEAS TRAN T_SOFTSTART WHEN V(DC_BUS)=300 RISE=1
.MEAS TRAN DC_BUS_MAX MAX V(DC_BUS) FROM=0 TO=400M

*------------------------------------------------------------------------------
* CONTROL SCRIPT
*------------------------------------------------------------------------------
.CONTROL

set filetype=ascii
set color0=white
set color1=black

echo ""
echo "============================================================"
echo "  Lesson 09: AC Input Stage Design Verification"
echo "  Full Bridge Rectifier + Soft-Start (22Ω + Relay)"
echo "  EMI Filter + 2200µF Bulk Capacitor"
echo "  Load: 2kW at 320V DC"
echo "============================================================"
echo ""

run

echo ""
echo "============================================================"
echo "RESULTS:"
echo "============================================================"

print i_inrush_peak
print dc_bus_avg dc_bus_ripple dc_bus_max
print t_softstart

echo ""
echo "============================================================"
echo "VERIFICATION:"
echo "============================================================"
echo ""
echo "Target 1: Inrush < 20A"
echo "  Design: R_precharge = 22Ω"
echo "  Expected: I = 340V/22Ω = 15.5A"

if i_inrush_peak < 20
  echo "  ✓ PASS"
else
  echo "  ✗ FAIL"
end

echo ""
echo "Target 2: DC Bus 300-340V"

if dc_bus_avg > 290 & dc_bus_avg < 350
  echo "  ✓ PASS"
else
  echo "  ✗ CHECK"
end

echo ""
echo "Target 3: Ripple < 50V at 2kW"
echo "  Design: C = 2200µF"
echo "  Expected: ΔV = I/(2fC) ≈ 14V"

if dc_bus_ripple < 50
  echo "  ✓ PASS"
else
  echo "  ✗ CHECK"
end

echo ""
echo "Target 4: Soft-start < 150ms"

if t_softstart < 0.15
  echo "  ✓ PASS"
else
  echo "  ⚠ SLOW"
end

echo ""
echo "============================================================"
echo "CIRCUIT SUMMARY:"
echo "============================================================"
echo "1. AC Input: 240VAC, 50Hz (340V peak)"
echo "2. EMI Filter: 100µH + 470nF pi-filter"
echo "3. Rectifier: Full bridge (GBU8K equivalent)"
echo "4. Soft-start: 22Ω pre-charge + relay bypass at 100ms"
echo "5. Bulk Cap: 2200µF electrolytic"
echo "6. Load: 51.2Ω = 2kW at 320V"
echo "============================================================"

wrdata sim_09_results.txt v(dc_bus) i(v_isense) v(n_line)

.ENDC

.END
