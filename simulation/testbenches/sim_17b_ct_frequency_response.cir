* Current Transformer Frequency Response Test
* sim_17b_ct_frequency_response.cir
*
* Tests CT frequency response from 1kHz to 500kHz
* Verifies flat response in the 20-100kHz operating range
***************************************************************************

.title CT Frequency Response Analysis

.include ../models/current_transformer.sub

***************************************************************************
* TEST CIRCUIT FOR AC ANALYSIS
***************************************************************************
* AC current source (1A magnitude for easy ratio calculation)
I_primary pri_p 0 AC 1

* Current transformer (1:1000 ratio)
X_ct pri_p 0 sec_p 0 CURRENT_TRANSFORMER N=1000 LM=10m LL=100u RW=50

* Burden resistor (66.5 ohm)
R_burden sec_p 0 66.5

***************************************************************************
* AC ANALYSIS: Frequency sweep
***************************************************************************
.ac dec 50 1k 500k

***************************************************************************
* Expected Results:
* At 1A primary, with 1:1000 ratio and 66.5 ohm burden:
* V_out = 1A / 1000 * 66.5 = 66.5mV
*
* Low frequency rolloff due to magnetizing inductance:
* f_low = R_burden / (2*pi*Lm) = 66.5 / (2*pi*10m) = 1.06 kHz
*
* High frequency rolloff due to leakage inductance:
* f_high = R_burden / (2*pi*Ll) = 66.5 / (2*pi*100u) = 105.8 kHz
***************************************************************************

.control
run

echo ""
echo "============================================"
echo "CT Frequency Response Analysis"
echo "============================================"
echo ""

* Measure gain at key frequencies
meas ac gain_1k FIND vdb(sec_p) AT=1k
meas ac gain_10k FIND vdb(sec_p) AT=10k
meas ac gain_20k FIND vdb(sec_p) AT=20k
meas ac gain_35k FIND vdb(sec_p) AT=35k
meas ac gain_50k FIND vdb(sec_p) AT=50k
meas ac gain_100k FIND vdb(sec_p) AT=100k
meas ac gain_200k FIND vdb(sec_p) AT=200k

* Measure phase at key frequencies
meas ac phase_35k FIND vp(sec_p) AT=35k

* Find -3dB frequencies
let ref_gain = gain_35k
meas ac f_low WHEN vdb(sec_p)=(ref_gain-3) FALL=1
meas ac f_high WHEN vdb(sec_p)=(ref_gain-3) RISE=LAST

echo ""
echo "Gain at Key Frequencies:"
echo "  1 kHz:"
print gain_1k
echo "  10 kHz:"
print gain_10k
echo "  20 kHz (operating range start):"
print gain_20k
echo "  35 kHz (nominal operating):"
print gain_35k
echo "  50 kHz:"
print gain_50k
echo "  100 kHz (operating range end):"
print gain_100k
echo "  200 kHz:"
print gain_200k
echo ""
echo "Phase at 35kHz:"
print phase_35k
echo ""
echo "-3dB Bandwidth:"
echo "  Low cutoff:"
print f_low
echo "  High cutoff:"
print f_high
echo ""

* Check flatness in operating band (20-100kHz)
let flatness = abs(gain_20k - gain_100k)
echo "Gain variation 20kHz-100kHz (dB):"
print flatness
echo ""

quit
.endc

.end
