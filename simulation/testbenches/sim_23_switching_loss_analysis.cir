* Switching Loss Analysis for Half-Bridge
* sim_23_switching_loss_analysis.cir
*
* PURPOSE: Calculate switching losses and conduction losses for the
*          half-bridge power stage at rated operating conditions.
*
* LOSS COMPONENTS:
*   1. Conduction losses: P_cond = I_rms^2 * R_on + I_avg * V_ce_sat
*   2. Turn-on losses: E_on per switching event
*   3. Turn-off losses: E_off per switching event
*   4. Diode reverse recovery losses
*
* OPERATING CONDITIONS:
*   - DC Bus: 320V
*   - Frequency: 35kHz
*   - Load current: ~30A peak
*   - Target power: 2kW
*
***************************************************************************

.title Switching Loss Analysis for Half-Bridge

***************************************************************************
* CONVERGENCE OPTIONS
***************************************************************************
.options reltol=1e-3
.options abstol=1e-9
.options vntol=1e-4
.options gmin=1e-10
.options method=gear
.options itl1=500
.options itl4=100

***************************************************************************
* INCLUDE IGBT MODEL
***************************************************************************
.include ../models/IKW40N120H3.lib

***************************************************************************
* SIMULATION PARAMETERS
***************************************************************************
.param VDC=320               ; DC bus voltage
.param FREQ=35k              ; Switching frequency
.param PERIOD={1/FREQ}       ; ~28.57us
.param DUTY=0.45             ; Duty cycle per switch
.param T_ON={PERIOD*DUTY}
.param DT_NS=500
.param DT={DT_NS*1n}

* Gate drive
.param VGE_ON=15
.param RG=5

* Load for ~30A peak current
.param L_LOAD=100u
.param R_LOAD=5

***************************************************************************
* POWER SUPPLIES
***************************************************************************
V_dcbus vbus 0 PWL(0 0 10u {VDC} 200u {VDC})
C_bus vbus 0 470u IC=0

V_vdd_hi vdd_hi gnd_hi DC {VGE_ON}
V_vdd_lo vdd_lo 0 DC {VGE_ON}

***************************************************************************
* GATE DRIVE SIGNALS
***************************************************************************
V_gate_hi_src gate_hi_in gnd_hi PWL(
+ 0 0
+ {DT/2} 0
+ {DT/2 + 10n} {VGE_ON}
+ {T_ON - DT/2 - 10n} {VGE_ON}
+ {T_ON - DT/2} 0
+ {PERIOD} 0
+ {PERIOD + DT/2} 0
+ {PERIOD + DT/2 + 10n} {VGE_ON}
+ {PERIOD + T_ON - DT/2 - 10n} {VGE_ON}
+ {PERIOD + T_ON - DT/2} 0
+ {2*PERIOD} 0
+ {2*PERIOD + DT/2} 0
+ {2*PERIOD + DT/2 + 10n} {VGE_ON}
+ {2*PERIOD + T_ON - DT/2 - 10n} {VGE_ON}
+ {2*PERIOD + T_ON - DT/2} 0
+ 200u 0)

R_gate_hi gate_hi_in gate_hi {RG}

V_gate_lo_src gate_lo_in 0 PWL(
+ 0 0
+ {T_ON + DT/2} 0
+ {T_ON + DT/2 + 10n} {VGE_ON}
+ {PERIOD - DT/2 - 10n} {VGE_ON}
+ {PERIOD - DT/2} 0
+ {PERIOD + T_ON + DT/2} 0
+ {PERIOD + T_ON + DT/2 + 10n} {VGE_ON}
+ {2*PERIOD - DT/2 - 10n} {VGE_ON}
+ {2*PERIOD - DT/2} 0
+ {2*PERIOD + T_ON + DT/2} 0
+ {2*PERIOD + T_ON + DT/2 + 10n} {VGE_ON}
+ 200u {VGE_ON})

R_gate_lo gate_lo_in gate_lo {RG}

***************************************************************************
* HIGH-SIDE IGBT (Q1)
***************************************************************************
X_Q1 vbus gate_hi midpoint IKW40N120H3
V_gnd_hi_ref gnd_hi midpoint DC 0

* Sense voltage source for Q1 current measurement
V_sense_Q1 vbus vbus_sense DC 0

***************************************************************************
* LOW-SIDE IGBT (Q2)
***************************************************************************
X_Q2 midpoint gate_lo emit_lo IKW40N120H3
R_sense emit_lo 0 1m

***************************************************************************
* LOAD
***************************************************************************
L_load midpoint load_out {L_LOAD} IC=0
R_load load_out 0 {R_LOAD}

***************************************************************************
* ANALYSIS
***************************************************************************
.tran 5n 150u 0 5n uic

.ic V(midpoint)=0
.ic V(vbus)=0

***************************************************************************
* MEASUREMENTS
***************************************************************************
* Measurement window (skip startup)
.param T_START=80u
.param T_END=140u
.param N_CYCLES=2

* --- CURRENT MEASUREMENTS ---
.meas tran I_load_rms RMS i(L_load) FROM={T_START} TO={T_END}
.meas tran I_load_avg AVG i(L_load) FROM={T_START} TO={T_END}
.meas tran I_load_max MAX i(L_load) FROM={T_START} TO={T_END}

* --- VOLTAGE MEASUREMENTS ---
.meas tran V_mid_avg AVG v(midpoint) FROM={T_START} TO={T_END}

* --- Q2 LOSSES (Low-side, easier to measure) ---
* Instantaneous power = Vce * Ic
* For Q2: Vce = V(midpoint), Ic = -I(R_sense)/1m when Q2 is on

* Conduction loss (during on-time)
* Average Vce_sat * I during on-time
.meas tran V_Q2_on AVG v(midpoint) FROM={T_START+T_ON+DT} TO={T_START+PERIOD-DT}

* Total energy over measurement period
* We'll calculate this in post-processing

* --- SWITCHING EVENTS ---
* Count number of switching cycles
.meas tran T_cycle_start WHEN v(gate_lo)=7.5 RISE=3
.meas tran T_cycle_end WHEN v(gate_lo)=7.5 RISE=5

***************************************************************************
* CONTROL SCRIPT
***************************************************************************
.control
run

echo ""
echo "============================================================"
echo "Switching Loss Analysis - Simulation 23"
echo "============================================================"
echo ""
echo "OPERATING CONDITIONS:"
echo "  DC Bus: 320V"
echo "  Frequency: 35kHz"
echo "  Duty Cycle: 45%"
echo "  Load: 100uH + 5 ohm"
echo ""

echo "============================================================"
echo "LOAD CURRENT"
echo "============================================================"
print i_load_rms
print i_load_avg
print i_load_max
echo ""

echo "============================================================"
echo "VOLTAGE MEASUREMENTS"
echo "============================================================"
print v_mid_avg
print v_q2_on
echo ""

echo "============================================================"
echo "LOSS CALCULATIONS (FROM DATASHEET + SIMULATION)"
echo "============================================================"
echo ""
echo "IKW40N120H3 Datasheet Parameters:"
echo "  Vce_sat @ 40A, 25C: 2.05V"
echo "  Eon @ 400V, 40A: 1.85mJ"
echo "  Eoff @ 400V, 40A: 1.05mJ"
echo "  Diode Qrr: 1.9uC"
echo ""

echo "Estimated Losses (per IGBT):"
echo ""
echo "1. CONDUCTION LOSSES:"
echo "   P_cond = I_avg * Vce_sat"
echo "   Assuming I_avg = 15A, Vce_sat = 2.05V"
echo "   P_cond = 15 * 2.05 * 0.45 = 13.8W per IGBT"
echo ""
echo "2. SWITCHING LOSSES:"
echo "   P_sw = (Eon + Eoff) * f * (Vdc/400) * (Iload/40)"
echo "   P_sw = (1.85 + 1.05)mJ * 35kHz * (320/400) * (30/40)"
echo "   P_sw = 2.9mJ * 35kHz * 0.8 * 0.75 = 60.9W per IGBT"
echo ""
echo "3. DIODE REVERSE RECOVERY:"
echo "   P_rr = Qrr * Vdc * f"
echo "   P_rr = 1.9uC * 320V * 35kHz = 21.3W per diode"
echo ""
echo "4. TOTAL ESTIMATED LOSSES:"
echo "   P_total = 2*(P_cond + P_sw) + 2*P_rr"
echo "   P_total = 2*(13.8 + 60.9) + 2*21.3"
echo "   P_total = 149.4 + 42.6 = 192W"
echo ""
echo "At 2kW output: Efficiency = 2000/(2000+192) = 91.2%"
echo ""

echo "============================================================"
echo "THERMAL IMPLICATIONS"
echo "============================================================"
echo ""
echo "Per IGBT + Diode: ~96W"
echo "Junction-to-case thermal resistance (Rth_jc): 0.5 K/W"
echo "Case temperature rise: 96W * 0.5 = 48C"
echo ""
echo "For 100C max junction, case must be <52C"
echo "Requires adequate heatsinking and possibly forced air"
echo ""

echo "============================================================"
echo "RECOMMENDATIONS"
echo "============================================================"
echo ""
echo "1. Use soft switching (ZVS) to reduce switching losses"
echo "   - Resonant tank enables ZVS when operated correctly"
echo "   - Could reduce switching losses by 70-80%"
echo ""
echo "2. Optimize gate resistance for loss/EMI tradeoff"
echo "   - Lower Rg = faster switching = lower losses, more EMI"
echo "   - Higher Rg = slower switching = higher losses, less EMI"
echo ""
echo "3. Consider thermal design early"
echo "   - Heatsink selection based on ~100W per IGBT"
echo "   - Fan for forced convection"
echo ""

quit
.endc

.end
