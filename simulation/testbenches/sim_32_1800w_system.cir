* 1800W System Integration Simulation
* sim_32_1800w_system.cir
*
* PURPOSE: Verify complete power delivery path at 1800W target
*          for 120V/15A outlet compatibility.
*
* SYSTEM SPECS:
*   - Input: 120VAC, 15A max (1800W)
*   - DC Bus: 170V (rectified, no PFC)
*   - Output: 1800W to induction coil/pan
*   - Switching: 38kHz, ZVS operation
*
***************************************************************************

.title 1800W Induction Cooker - Full System Verification

***************************************************************************
* SIMULATION PARAMETERS
***************************************************************************
.param VDC=170              ; DC bus from rectified 120VAC
.param F_SW=38k             ; Switching frequency (above resonance)
.param P_TARGET=1800        ; Target output power (W)
.param PERIOD={1/F_SW}
.param DUTY=0.47            ; Duty cycle per switch
.param DT=500n              ; Dead-time

* Resonant tank parameters
.param C_RES=330n           ; Resonant capacitor
.param L_EFF=60u            ; Effective inductance (with pan)
.param R_PAN=8              ; Cast iron pan reflected resistance
.param R_COIL=0.22          ; Coil AC resistance at 80°C

* Gate drive
.param VGE_ON=15
.param RG=5

***************************************************************************
* EXPECTED VALUES (for verification)
***************************************************************************
* At 1800W into 8 ohm:
*   I_rms = sqrt(1800/8) = 15.0A
*   I_peak = 15 * sqrt(2) = 21.2A
*
* Coil loss: I²R = 15² * 0.22 = 49.5W
* Efficiency: 1800 / (1800 + 49.5) = 97.3%

***************************************************************************
* INCLUDE MODELS
***************************************************************************
.include ../models/IKW40N120H3.lib

***************************************************************************
* DC BUS
***************************************************************************
V_bus vbus 0 PWL(0 0 100u {VDC} 5m {VDC})
C_bus vbus 0 470u IC={VDC}
C_film vbus 0 1u

* Split bus for resonant return
R_mid1 vbus vmid 100k
R_mid2 vmid 0 100k
C_mid1 vbus vmid 100u IC={VDC/2}
C_mid2 vmid 0 100u IC={VDC/2}

***************************************************************************
* GATE DRIVE SIGNALS (Complementary PWM with dead-time)
***************************************************************************
* High-side gate: ON from DT/2 to DUTY*PERIOD
V_pwm_hi gate_hi 0 PULSE(0 {VGE_ON} {DT/2} 10n 10n {DUTY*PERIOD-DT} {PERIOD})

* Low-side gate: ON from DUTY*PERIOD+DT to end of period
V_pwm_lo gate_lo 0 PULSE(0 {VGE_ON} {DUTY*PERIOD+DT} 10n 10n {(1-DUTY)*PERIOD-DT} {PERIOD})

***************************************************************************
* HALF-BRIDGE POWER STAGE
***************************************************************************
* High-side IGBT
X_Q1 vbus gate_hi midpoint IKW40N120H3

* Low-side IGBT
X_Q2 midpoint gate_lo 0 IKW40N120H3

***************************************************************************
* RESONANT TANK + PAN LOAD
***************************************************************************
* Resonant capacitor
C_res midpoint n_cap {C_RES} IC=0
R_cap_esr n_cap n_cap2 0.01

* Induction coil (effective inductance with pan coupling)
L_coil n_cap2 n_l {L_EFF} IC=0

* Coil AC resistance (where coil heat is generated)
R_coil n_l n_r {R_COIL}

* Pan reflected resistance (where useful power goes)
R_pan n_r vmid {R_PAN}

***************************************************************************
* ANALYSIS
***************************************************************************
.tran 500n 5m 0 200n uic

* Steady-state measurement window (after tank builds up)
.param T_START=4m
.param T_END=5m

* Current measurements
.meas tran I_tank_rms RMS i(L_coil) FROM={T_START} TO={T_END}
.meas tran I_tank_peak MAX i(L_coil) FROM={T_START} TO={T_END}
.meas tran I_bus_avg AVG i(V_bus) FROM={T_START} TO={T_END}

* Voltage measurements
.meas tran V_bus_avg AVG v(vbus) FROM={T_START} TO={T_END}
.meas tran V_mid_max MAX v(midpoint) FROM={T_START} TO={T_END}
.meas tran V_mid_min MIN v(midpoint) FROM={T_START} TO={T_END}
.meas tran V_cap_peak MAX v(n_cap) FROM={T_START} TO={T_END}

***************************************************************************
* CONTROL SCRIPT
***************************************************************************
.control
set wr_vecnames

run

* Calculate power from measurements
let i_tank = i(l_coil)
meas tran i_rms RMS i_tank from=4m to=5m
meas tran i_peak MAX i_tank from=4m to=5m

let r_pan = 8
let r_coil = 0.22
let p_pan = i_rms * i_rms * r_pan
let p_coil = i_rms * i_rms * r_coil
let p_total = p_pan + p_coil
let eff = p_pan / p_total * 100

echo ""
echo "============================================================"
echo "1800W SYSTEM VERIFICATION - Simulation 32"
echo "============================================================"
echo ""
echo "TARGET SPECIFICATIONS:"
echo "  Input: 120VAC / 15A (1800W max)"
echo "  DC Bus: 170V"
echo "  Output Power: 1800W"
echo "  Pan Resistance: 8 ohm"
echo ""

echo "============================================================"
echo "OPERATING POINT"
echo "============================================================"
echo ""
echo "Switching frequency: 38 kHz"
echo "Resonant frequency: ~35.8 kHz"
echo "Dead-time: 500 ns"
echo ""

echo "============================================================"
echo "MEASURED RESULTS"
echo "============================================================"
print i_rms
print i_peak
print v_bus_avg
print v_mid_max
print v_mid_min
print v_cap_peak
echo ""

echo "============================================================"
echo "POWER ANALYSIS"
echo "============================================================"
print p_pan
print p_coil
print p_total
print eff
echo ""

echo "============================================================"
echo "THERMAL IMPACT"
echo "============================================================"
echo ""
echo "IGBT losses (estimated with ZVS):"
echo "  Conduction: ~24W (both)"
echo "  Switching: ~8W (both, ZVS)"
echo "  Diode: ~6W (both)"
echo "  Total IGBT: ~38W"
echo ""
echo "Coil losses:"
print p_coil
echo ""
echo "TOTAL SYSTEM HEAT:"
echo "  IGBTs + Coil = ~38W + ~50W = ~88W"
echo ""

echo "============================================================"
echo "VERIFICATION CRITERIA"
echo "============================================================"
echo ""
echo "Target I_rms for 1800W: 15.0A"
echo "Target P_pan: 1800W"
echo "Target efficiency: >95%"
echo ""

echo "============================================================"
echo "ZVS VERIFICATION"
echo "============================================================"
echo ""
echo "V_mid_min should be <10V for ZVS"
print v_mid_min
echo ""
echo "If V_mid_min << Vbus, ZVS is achieved"
echo ""

quit
.endc

.end
