* Simulation 15: UCC21550 Dead-Time Generation and Propagation Delays
* ============================================================================
* Purpose: Verify UCC21550 gate driver dead-time generation and propagation
*          delay specifications for induction cooker half-bridge application
*
* Test Objectives:
* 1. Verify propagation delay (tPD) from input to output (target: 26-45ns typ)
* 2. Verify propagation delay matching between channels (<5ns max)
* 3. Verify pulse width distortion (PWD) <5ns max
* 4. Verify dead-time programming via RDT resistor (DT = 8.6×RDT + 13ns)
* 5. Verify output rise/fall times with realistic IGBT gate load
*
* SIMPLIFIED MODEL for timing analysis only (no full power stage)
*
* References:
* - UCC21550 Datasheet (Texas Instruments)
* - components/UCC21550/UCC21550_Documentation.md
* - GATE_DRIVER_POWER_ARCHITECTURE_DECISION.md (bootstrap selected)
*
* ============================================================================

.title UCC21550 Dead-Time and Propagation Delay Verification

* ============================================================================
* SIMULATION PARAMETERS
* ============================================================================

.param FREQ=50kHz              ; Switching frequency (typical induction cooker)
.param PERIOD={1/FREQ}         ; Switching period (20us)
.param DUTY=0.45               ; Duty cycle per transistor (45% each)
.param T_ON={PERIOD*DUTY}      ; On-time per transistor (9us)
.param DT_INPUT=1us            ; Dead-time in input signals (1us initial)

* Dead-time programming resistor values to test
.param RDT=20k                 ; 20kOhm → 185ns dead-time
*.param RDT=10k                ; 10kOhm → 99ns dead-time
*.param RDT=50k                ; 50kOhm → 443ns dead-time

* Gate load parameters (IKW40N120H3 IGBT)
.param CG_TOTAL=7.5n           ; Total gate capacitance (CGS + CGD)

* Power supply levels
.param VCCI=5.0                ; Primary-side supply
.param VDD=15.0                ; Secondary-side gate drive supply

* Driver parameters (from datasheet)
.param TPD=33n                 ; Propagation delay (typical)
.param ISOURCE=4.0             ; Peak source current
.param ISINK=6.0               ; Peak sink current
.param RON=1.0                 ; Output resistance when sourcing
.param ROFF=0.6                ; Output resistance when sinking

* ============================================================================
* SIMPLIFIED BEHAVIORAL MODEL: UCC21550 TIMING ONLY
* ============================================================================
* Focuses on propagation delay and dead-time generation
* Omits isolation barrier, UVLO, disable for simulation simplicity

.subckt UCC21550_TIMING INA INB GND DT OUTA GND_A OUTB GND_B VDD

* Propagation delay elements (simple RC delay)
* Channel A
RINA_PD INA N_INA_DEL 1k
CINA_PD N_INA_DEL GND {TPD/1k}
EINA_BUF N_INA_BUF GND N_INA_DEL GND 1

* Channel B
RINB_PD INB N_INB_DEL 1k
CINB_PD N_INB_DEL GND {TPD/1k}
EINB_BUF N_INB_BUF GND N_INB_DEL GND 1

* Dead-time generation (resistor programmable)
* DT_ns = 8.6 * RDT_kOhm + 13
* We'll add additional delay based on RDT value
.param DT_PROG_NS={8.6*RDT/1k + 13}
.param DT_PROG_S={DT_PROG_NS*1n}

* Additional dead-time delay for Channel A
RINA_DT N_INA_BUF N_INA_DT 1k
CINA_DT N_INA_DT GND {DT_PROG_S/1k}
EINA_DT N_INA_OUT GND N_INA_DT GND 1

* Additional dead-time delay for Channel B
RINB_DT N_INB_BUF N_INB_DT 1k
CINB_DT N_INB_DT GND {DT_PROG_S/1k}
EINB_DT N_INB_OUT GND N_INB_DT GND 1

* Output driver stages (voltage-controlled current sources)
* Channel A: Drives from VDD to OUTA with source/sink capability
GOUTA VDD OUTA VALUE={
+  V(N_INA_OUT,GND)>{VCCI/2} ?
+    ISOURCE*TANH((V(VDD,OUTA))/RON) :
+    -ISINK*TANH((V(OUTA,GND_A))/ROFF)
+}

* Channel B
GOUTB VDD OUTB VALUE={
+  V(N_INB_OUT,GND)>{VCCI/2} ?
+    ISOURCE*TANH((V(VDD,OUTB))/RON) :
+    -ISINK*TANH((V(OUTB,GND_B))/ROFF)
+}

.ends UCC21550_TIMING

* ============================================================================
* POWER SUPPLIES
* ============================================================================

VVCCI VCCI 0 DC {VCCI}
VVDD VDD 0 DC {VDD}

* Decoupling caps
CVCCI VCCI 0 1u
CVDD VDD 0 1u

* ============================================================================
* INPUT SIGNAL GENERATION
* ============================================================================
* Complementary PWM with dead-time

VIN_A INA 0 PULSE(0 {VCCI} 0 10n 10n {T_ON} {PERIOD})
VIN_B INB 0 PULSE(0 {VCCI} {T_ON+DT_INPUT} 10n 10n {T_ON} {PERIOD})

* Input series resistors (noise filtering)
RINA INA N_INA_FILT 51
RINB INB N_INB_FILT 51
CINA N_INA_FILT 0 33p
CINB N_INB_FILT 0 33p

* Dead-time programming resistor
RDT DT_PIN 0 {RDT}

* ============================================================================
* GATE DRIVER INSTANTIATION
* ============================================================================

XDRV N_INA_FILT N_INB_FILT 0 DT_PIN OUTA 0 OUTB 0 VDD UCC21550_TIMING

* ============================================================================
* GATE LOAD (IGBT Gate Capacitance)
* ============================================================================

* Channel A gate drive circuit
RGATE_A_ON OUTA N_GATE_A 2.2   ; Turn-on resistor
CG_A N_GATE_A 0 {CG_TOTAL}     ; Gate capacitance
RGS_A N_GATE_A 0 10k           ; Gate-source pull-down

* Channel B gate drive circuit
RGATE_B_ON OUTB N_GATE_B 2.2
CG_B N_GATE_B 0 {CG_TOTAL}
RGS_B N_GATE_B 0 10k

* ============================================================================
* ANALYSIS
* ============================================================================

.tran 0.1n 100u 0 0.1n

* Initial conditions
.ic V(N_GATE_A)=0
.ic V(N_GATE_B)=0

* ============================================================================
* MEASUREMENTS
* ============================================================================

* Measurement window: second switching cycle
.param T_START=20u
.param T_END=40u

* ----- Propagation Delay (Input to Output) -----

* Channel A rising edge
.meas tran T_INA_RISE WHEN V(N_INA_FILT)={VCCI/2} RISE=2
.meas tran T_OUTA_RISE WHEN V(OUTA)={VDD/2} RISE=2
.meas tran TPD_A_RISE PARAM='(T_OUTA_RISE-T_INA_RISE)*1e9'

* Channel A falling edge
.meas tran T_INA_FALL WHEN V(N_INA_FILT)={VCCI/2} FALL=2
.meas tran T_OUTA_FALL WHEN V(OUTA)={VDD/2} FALL=2
.meas tran TPD_A_FALL PARAM='(T_OUTA_FALL-T_INA_FALL)*1e9'

* Channel B rising edge
.meas tran T_INB_RISE WHEN V(N_INB_FILT)={VCCI/2} RISE=2
.meas tran T_OUTB_RISE WHEN V(OUTB)={VDD/2} RISE=2
.meas tran TPD_B_RISE PARAM='(T_OUTB_RISE-T_INB_RISE)*1e9'

* Channel B falling edge
.meas tran T_INB_FALL WHEN V(N_INB_FILT)={VCCI/2} FALL=2
.meas tran T_OUTB_FALL WHEN V(OUTB)={VDD/2} FALL=2
.meas tran TPD_B_FALL PARAM='(T_OUTB_FALL-T_INB_FALL)*1e9'

* Average propagation delay
.meas tran TPD_AVG PARAM='(TPD_A_RISE+TPD_A_FALL+TPD_B_RISE+TPD_B_FALL)/4'

* ----- Channel-to-Channel Matching -----

.meas tran TPD_MATCH_RISE PARAM='ABS(TPD_A_RISE - TPD_B_RISE)'
.meas tran TPD_MATCH_FALL PARAM='ABS(TPD_A_FALL - TPD_B_FALL)'
.meas tran TPD_MATCH_MAX PARAM='MAX(TPD_MATCH_RISE, TPD_MATCH_FALL)'

* ----- Pulse Width Distortion -----

.meas tran T_INA_WIDTH PARAM='(T_INA_FALL - T_INA_RISE)*1e9'
.meas tran T_OUTA_WIDTH PARAM='(T_OUTA_FALL - T_OUTA_RISE)*1e9'
.meas tran PWD_A PARAM='ABS(T_OUTA_WIDTH - T_INA_WIDTH)'

.meas tran T_INB_WIDTH PARAM='(T_INB_FALL - T_INB_RISE)*1e9'
.meas tran T_OUTB_WIDTH PARAM='(T_OUTB_FALL - T_OUTB_RISE)*1e9'
.meas tran PWD_B PARAM='ABS(T_OUTB_WIDTH - T_INB_WIDTH)'

* ----- Dead-Time at Outputs -----

.meas tran DT_OUT_A_TO_B PARAM='(T_OUTB_RISE - T_OUTA_FALL)*1e9'
.meas tran DT_OUT_B_TO_A PARAM='(T_OUTA_RISE - T_OUTB_FALL)*1e9'

* ----- Dead-Time at IGBT Gates -----

.param VGE_TH=5.0

.meas tran T_GATE_A_FALL WHEN V(N_GATE_A)=VGE_TH FALL=2
.meas tran T_GATE_B_RISE WHEN V(N_GATE_B)=VGE_TH RISE=2
.meas tran DT_GATE_A_TO_B PARAM='(T_GATE_B_RISE - T_GATE_A_FALL)*1e9'

.meas tran T_GATE_B_FALL WHEN V(N_GATE_B)=VGE_TH FALL=2
.meas tran T_GATE_A_RISE WHEN V(N_GATE_A)=VGE_TH RISE=2
.meas tran DT_GATE_B_TO_A PARAM='(T_GATE_A_RISE - T_GATE_B_FALL)*1e9'

.meas tran DT_GATE_MIN PARAM='MIN(DT_GATE_A_TO_B, DT_GATE_B_TO_A)'

* ----- Rise/Fall Times (20%-80%) -----

.meas tran T_OUTA_20R WHEN V(OUTA)={0.2*VDD} RISE=2
.meas tran T_OUTA_80R WHEN V(OUTA)={0.8*VDD} RISE=2
.meas tran TRISE_OUTA PARAM='(T_OUTA_80R - T_OUTA_20R)*1e9'

.meas tran T_OUTA_80F WHEN V(OUTA)={0.8*VDD} FALL=2
.meas tran T_OUTA_20F WHEN V(OUTA)={0.2*VDD} FALL=2
.meas tran TFALL_OUTA PARAM='(T_OUTA_20F - T_OUTA_80F)*1e9'

.meas tran T_OUTB_20R WHEN V(OUTB)={0.2*VDD} RISE=2
.meas tran T_OUTB_80R WHEN V(OUTB)={0.8*VDD} RISE=2
.meas tran TRISE_OUTB PARAM='(T_OUTB_80R - T_OUTB_20R)*1e9'

.meas tran T_OUTB_80F WHEN V(OUTB)={0.8*VDD} FALL=2
.meas tran T_OUTB_20F WHEN V(OUTB)={0.2*VDD} FALL=2
.meas tran TFALL_OUTB PARAM='(T_OUTB_20F - T_OUTB_80F)*1e9'

* ----- Output Voltage Levels -----

.meas tran V_OUTA_HIGH MAX V(OUTA) FROM={T_START} TO={T_END}
.meas tran V_OUTA_LOW MIN V(OUTA) FROM={T_START} TO={T_END}
.meas tran V_OUTB_HIGH MAX V(OUTB) FROM={T_START} TO={T_END}
.meas tran V_OUTB_LOW MIN V(OUTB) FROM={T_START} TO={T_END}

* ============================================================================
* SIMULATION CONTROL
* ============================================================================

.control
run

echo ""
echo "============================================"
echo "UCC21550 Dead-Time and Propagation Delay"
echo "Simulation Results Summary"
echo "============================================"
echo ""
echo "Test Configuration:"
print FREQ PERIOD T_ON DT_INPUT
echo "  Switching Frequency: 50 kHz"
echo "  Input Dead-Time: 1.0 us"
print RDT
echo "  RDT Programming Resistor: 20 kOhm"
print DT_PROG_NS
echo "  Expected Hardware DT: 185 ns (from formula DT=8.6*RDT+13)"
print CG_TOTAL
echo "  IGBT Gate Capacitance: 7.5 nF"
echo ""
echo "--------------------------------------------"
echo "PROPAGATION DELAY RESULTS"
echo "--------------------------------------------"
print TPD_A_RISE TPD_A_FALL TPD_B_RISE TPD_B_FALL TPD_AVG
echo "  Datasheet Spec: 26-45 ns (typical 33ns)"
echo ""
echo "--------------------------------------------"
echo "CHANNEL MATCHING RESULTS"
echo "--------------------------------------------"
print TPD_MATCH_RISE TPD_MATCH_FALL TPD_MATCH_MAX
echo "  Datasheet Spec: <5 ns max"
echo ""
echo "--------------------------------------------"
echo "PULSE WIDTH DISTORTION RESULTS"
echo "--------------------------------------------"
print PWD_A PWD_B
echo "  Datasheet Spec: <5 ns max"
echo ""
echo "--------------------------------------------"
echo "DEAD-TIME RESULTS"
echo "--------------------------------------------"
echo "Output Dead-Time (driver outputs):"
print DT_OUT_A_TO_B DT_OUT_B_TO_A
echo ""
echo "Gate Dead-Time (at IGBT gates, including RC delays):"
print DT_GATE_A_TO_B DT_GATE_B_TO_A DT_GATE_MIN
echo "  Input Dead-Time: 1000 ns"
echo "  Hardware Dead-Time Added: 185 ns (from RDT=20k)"
echo "  Minimum Safe Dead-Time: >500 ns (prevents shoot-through)"
echo ""
echo "--------------------------------------------"
echo "RISE/FALL TIME RESULTS"
echo "--------------------------------------------"
print TRISE_OUTA TFALL_OUTA TRISE_OUTB TFALL_OUTB
echo "  Target: <100 ns with 7.5nF gate load"
echo ""
echo "--------------------------------------------"
echo "OUTPUT VOLTAGE LEVELS"
echo "--------------------------------------------"
print V_OUTA_HIGH V_OUTA_LOW V_OUTB_HIGH V_OUTB_LOW
echo "  Expected: HIGH = 15V, LOW = 0V"
echo ""
echo "============================================"
echo ""

* Generate plots
set hcopydevtype=postscript
set color0=white
set color1=black

* Plot 1: Input and output signals (full overview)
plot V(N_INA_FILT) V(N_INB_FILT)+6 V(OUTA)+12 V(OUTB)+18 xlimit 20u 60u
+ title 'Input and Output Signals - Full Overview'
+ xlabel 'Time (us)' ylabel 'Voltage (V, offset)'

* Plot 2: Propagation delay detail (rising edge)
plot V(N_INA_FILT) V(OUTA) xlimit 20u 20.5u
+ title 'Propagation Delay - Channel A Rising Edge'
+ xlabel 'Time (us)' ylabel 'Voltage (V)'

* Plot 3: Dead-time detail (transition region)
plot V(OUTA) V(OUTB) xlimit 28.8u 29.4u
+ title 'Dead-Time Between Outputs'
+ xlabel 'Time (us)' ylabel 'Voltage (V)'

* Plot 4: IGBT gate voltages
plot V(N_GATE_A) V(N_GATE_B) xlimit 20u 60u
+ title 'IGBT Gate Voltages'
+ xlabel 'Time (us)' ylabel 'Voltage (V)'

* Plot 5: Dead-time at gates (zoomed)
plot V(N_GATE_A) V(N_GATE_B) xlimit 28.8u 29.4u
+ title 'Dead-Time at IGBT Gates (Threshold Crossings)'
+ xlabel 'Time (us)' ylabel 'Gate Voltage (V)'

quit
.endc

.end
