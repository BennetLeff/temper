* LED Current Limiter Test
* Lesson 02: Validate SPICE Fundamentals

* Circuit Description
V1 vcc 0 DC 3.3
R1 vcc led_anode 150
D1 led_anode 0 LED_MODEL

* LED Model Definition
.model LED_MODEL D(Is=1e-20 N=1.5 Rs=0.5 Vj=1.8)

* Analysis: Transient analysis for 10ms
.tran 10u 10m

* Control Block for automated measurement
.control
run
* Plotting would happen in interactive mode, but we print measurement here
print v(led_anode)
* Measure average current (negated v1#branch)
meas tran Iled AVG v1#branch FROM=5m TO=10m
.endc

.end
