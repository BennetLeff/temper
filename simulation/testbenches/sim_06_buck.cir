* LMR51430 24V to 5V Buck Converter
* Lesson 06

* Parameters
.param Vin_val=24
.param Vout_target=5.0
.param Vref=0.8

* Circuit Description
Vin vin 0 DC {Vin_val}

* Include the model
.include simulation/models/LMR51430_avg.lib

X1 vin sw 0 fb LMR51430

* Output LC filter
* L=10u, C=47u (Increased from 22u to meet transient spec)
L1 sw vout 10u IC=0.1
C1 vout 0 47u IC=5.0

* Feedback Divider
* Vout = Vref * (1 + R1/R2)
* 5.0 = 0.8 * (1 + R1/R2) => R1/R2 = 5.25
* Let R2 = 20k
* R1 = 5.25 * 20k = 105k
R1 vout fb 105k
R2 fb 0 20k

* Dynamic Load Step
* 100mA to 600mA at 1ms
I_load vout 0 PWL(0 0.1 1m 0.1 1.001m 0.6 3m 0.6)

* Analysis
.tran 1u 3m UIC

* Control Block
.control
run
* Debug
meas tran Vfb_avg AVG v(fb)
meas tran Vsw_avg AVG v(sw)
meas tran Vout_avg AVG v(vout)
print Vfb_avg Vsw_avg Vout_avg

* Measure Regulation
meas tran Vout_steady AVG v(vout) FROM=0.5m TO=0.9m

* Measure Load Step Dip
meas tran Vmin MIN v(vout) FROM=1m TO=1.5m
let Vdip = Vout_steady - Vmin

* Measure Recovery Time
* Time to return to within 2% of steady state (4.9V)
let Vrecov_target = 0.98 * 5.0
meas tran Trecovery WHEN v(vout)=Vrecov_target RISE=1 FROM=1m TO=2m

print Vout_steady Vmin Vdip Trecovery

* Check for Brownout (<4.75V)
if Vmin < 4.75
  print "FAIL: Vmin below 4.75V"
else
  print "PASS: Vmin above 4.75V"
end
.endc
.end
