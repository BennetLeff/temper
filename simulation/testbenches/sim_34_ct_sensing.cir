* Current Transformer Sensing Verification
* sim_34_ct_sensing.cir
*
***************************************************************************

.title Current Transformer Sensing Verification

***************************************************************************
* PARAMETERS
***************************************************************************
.param N_RATIO=1000          ; Turns ratio (1:1000)
.param R_BURDEN=66.5         ; Burden resistor
.param F_SW=40k              ; Redesign switching frequency
.param I_PEAK_MAX=50         ; Max peak current for measurement

***************************************************************************
* TEST CIRCUIT
***************************************************************************
* Primary Current Simulation
* Use a voltage source to represent I_pri (1V = 1A)
V_pri n_pri 0 SINE(0 {I_PEAK_MAX} {F_SW}) AC 1

* Secondary Current (I_sec = I_pri / N)
* Use a VCVS to generate burden voltage directly: V_sec = (V_pri * 1) * (1/N) * R_burden
E_ct_sec n_sec 0 n_pri 0 {R_BURDEN / N_RATIO}

* Load at secondary (just for circuit completeness)
R_load_sec n_sec 0 1Meg

* Ideal Rectifier
E_rect n_rect 0 VALUE={ABS(V(n_sec))}

* Low Pass Filter (RC)
R_filt n_rect n_adc 1k
C_filt n_adc 0 100n

***************************************************************************
* ANALYSIS
***************************************************************************
.tran 100n 200u
.ac dec 100 10 10Meg

***************************************************************************
* CONTROL SCRIPT
***************************************************************************
.control
run

echo ""
echo "============================================================"
echo "CT Sensing Verification - Simulation 34"
echo "============================================================"
echo ""

* Measure peak voltages
setplot tran1
meas tran V_burden_peak MAX v(n_sec) from=100u to=200u
meas tran V_adc_avg AVG v(n_adc) from=100u to=200u

echo "RESULTS:"
let v_expected = 50 * 66.5 / 1000
echo "  Expected Burden Voltage (peak): $&v_expected V"
echo "  Actual Burden Voltage (peak):   $&V_burden_peak V"
echo "  Filtered ADC Average Voltage:   $&V_adc_avg V"
echo ""

echo "BANDWIDTH CHECK:"
setplot ac1
* Find DC gain
let gain_dc = v(n_adc)[0]
* Find -3dB point relative to n_sec peak (which is our secondary signal)
meas ac bandwidth_3db when vdb(n_adc)=-3
echo "  -3dB Bandwidth: $&bandwidth_3db Hz"
echo ""

quit
.endc

.end
