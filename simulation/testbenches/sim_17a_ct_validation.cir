* Current Transformer Model Validation
* sim_17a_ct_validation.cir
*
* Validates the current_transformer.sub model
***************************************************************************

.title Current Transformer Model Validation

.include ../models/current_transformer.sub

***************************************************************************
* TEST CIRCUIT
***************************************************************************
* Primary current source: 50A peak sinusoidal at 35kHz
I_primary pri_p 0 SIN(0 50 35k)

* Current transformer (1:1000 ratio)
X_ct pri_p 0 sec_p 0 CURRENT_TRANSFORMER N=1000 LM=10m LL=100u RW=50

* Burden resistor (66.5 ohm)
R_burden sec_p 0 66.5

* Expected: V_out = 50A / 1000 * 66.5Ω = 3.325V peak

***************************************************************************
* ANALYSIS
***************************************************************************
.tran 0.2u 300u uic

* Measurements
.meas tran v_sec_peak MAX v(sec_p) FROM=100u TO=300u
.meas tran v_sec_min MIN v(sec_p) FROM=100u TO=300u
.meas tran v_sec_pp PARAM='v_sec_peak - v_sec_min'

.end
