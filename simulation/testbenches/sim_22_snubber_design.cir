* RC Snubber Design and Optimization
* sim_22_snubber_design.cir
*
* PURPOSE: Design and optimize RC snubber circuits for the half-bridge
*          power stage to limit dV/dt during switching and reduce
*          voltage overshoot.
*
* SNUBBER THEORY:
*   Without snubber: High dV/dt causes EMI and stress on IGBTs
*   RC Snubber: Limits dV/dt, absorbs energy during turn-off
*   Design equations:
*     C_snub > I_peak * t_fall / (V_overshoot_allowed)
*     R_snub = sqrt(L_stray / C_snub) for critically damped
*
* TEST CONFIGURATION:
*   - DC Bus: 320V
*   - Switching frequency: 35kHz
*   - Load current: ~30A
*   - Compare: No snubber vs. RC snubber
*
***************************************************************************

.title RC Snubber Design and Optimization

***************************************************************************
* CONVERGENCE OPTIONS
***************************************************************************
.options reltol=1e-3
.options abstol=1e-9
.options vntol=1e-4
.options gmin=1e-10
.options method=gear
.options itl1=500
.options itl4=100

***************************************************************************
* INCLUDE IGBT MODEL
***************************************************************************
.include ../models/IKW40N120H3.lib

***************************************************************************
* SIMULATION PARAMETERS
***************************************************************************
.param VDC=320               ; DC bus voltage
.param FREQ=35k              ; Switching frequency
.param PERIOD={1/FREQ}       ; ~28.57us
.param DUTY=0.45             ; Duty cycle per switch
.param T_ON={PERIOD*DUTY}    ; On-time (~12.86us)
.param DT_NS=500             ; Dead-time in ns
.param DT={DT_NS*1n}         ; Dead-time in seconds

* Gate drive parameters
.param VGE_ON=15             ; Gate drive voltage
.param RG=5                  ; Gate resistor

* Load parameters
.param L_LOAD=100u           ; Load inductance
.param R_LOAD=5              ; Load resistance

* Snubber parameters (to be optimized)
.param C_SNUB=10n            ; Snubber capacitor
.param R_SNUB=10             ; Snubber resistor

* Stray inductance (PCB + wiring)
.param L_STRAY=50n           ; ~50nH typical for good layout

***************************************************************************
* POWER SUPPLIES
***************************************************************************
* DC Bus with soft-start
V_dcbus vbus_src 0 PWL(0 0 10u {VDC} 200u {VDC})

* Stray inductance in bus path
L_stray_pos vbus_src vbus {L_STRAY/2}
L_stray_neg 0 gnd_stray {L_STRAY/2}

* Bus capacitor
C_bus vbus gnd_stray 470u IC=0

* Gate driver supplies
V_vdd_hi vdd_hi gnd_hi DC {VGE_ON}
V_vdd_lo vdd_lo gnd_stray DC {VGE_ON}

***************************************************************************
* GATE DRIVE SIGNALS
***************************************************************************
* High-side gate signal (Q1)
V_gate_hi_src gate_hi_in gnd_hi PWL(
+ 0 0
+ {DT/2} 0
+ {DT/2 + 10n} {VGE_ON}
+ {T_ON - DT/2 - 10n} {VGE_ON}
+ {T_ON - DT/2} 0
+ {PERIOD} 0
+ {PERIOD + DT/2} 0
+ {PERIOD + DT/2 + 10n} {VGE_ON}
+ {PERIOD + T_ON - DT/2 - 10n} {VGE_ON}
+ {PERIOD + T_ON - DT/2} 0
+ {2*PERIOD} 0
+ {2*PERIOD + DT/2} 0
+ {2*PERIOD + DT/2 + 10n} {VGE_ON}
+ {2*PERIOD + T_ON - DT/2 - 10n} {VGE_ON}
+ {2*PERIOD + T_ON - DT/2} 0
+ 200u 0)

R_gate_hi gate_hi_in gate_hi {RG}

* Low-side gate signal (Q2)
V_gate_lo_src gate_lo_in gnd_stray PWL(
+ 0 0
+ {T_ON + DT/2} 0
+ {T_ON + DT/2 + 10n} {VGE_ON}
+ {PERIOD - DT/2 - 10n} {VGE_ON}
+ {PERIOD - DT/2} 0
+ {PERIOD + T_ON + DT/2} 0
+ {PERIOD + T_ON + DT/2 + 10n} {VGE_ON}
+ {2*PERIOD - DT/2 - 10n} {VGE_ON}
+ {2*PERIOD - DT/2} 0
+ {2*PERIOD + T_ON + DT/2} 0
+ {2*PERIOD + T_ON + DT/2 + 10n} {VGE_ON}
+ 200u {VGE_ON})

R_gate_lo gate_lo_in gate_lo {RG}

***************************************************************************
* HIGH-SIDE IGBT (Q1) WITH SNUBBER
***************************************************************************
X_Q1 vbus gate_hi midpoint IKW40N120H3

* High-side snubber (across collector-emitter)
R_snub_hi snub_hi_r midpoint {R_SNUB}
C_snub_hi vbus snub_hi_r {C_SNUB} IC=0

* High-side gate ground reference
V_gnd_hi_ref gnd_hi midpoint DC 0

***************************************************************************
* LOW-SIDE IGBT (Q2) WITH SNUBBER
***************************************************************************
X_Q2 midpoint gate_lo emit_lo IKW40N120H3

* Low-side snubber (across collector-emitter)
R_snub_lo snub_lo_r gnd_stray {R_SNUB}
C_snub_lo midpoint snub_lo_r {C_SNUB} IC=0

* Current sense resistor
R_sense emit_lo gnd_stray 1m

***************************************************************************
* LOAD
***************************************************************************
L_load midpoint load_out {L_LOAD} IC=0
R_load load_out gnd_stray {R_LOAD}

***************************************************************************
* ANALYSIS
***************************************************************************
.tran 5n 100u 0 5n uic

.ic V(midpoint)=0
.ic V(vbus)=0

***************************************************************************
* MEASUREMENTS
***************************************************************************
.param T_START=60u
.param T_END=100u

* --- VOLTAGE MEASUREMENTS ---
.meas tran V_mid_max MAX v(midpoint) FROM={T_START} TO={T_END}
.meas tran V_mid_min MIN v(midpoint) FROM={T_START} TO={T_END}

* Overshoot during Q1 turn-off (midpoint goes negative)
.meas tran V_undershoot MIN v(midpoint) FROM={T_START} TO={T_END}

* Overshoot during Q2 turn-off (midpoint goes above VDC)
.meas tran V_overshoot MAX v(midpoint) FROM={T_START} TO={T_END}
.meas tran V_overshoot_pct PARAM='(V_overshoot - VDC) / VDC * 100'

* --- dV/dt MEASUREMENTS ---
* Approximate dV/dt from rise time
.meas tran T_mid_rise_10 WHEN v(midpoint)={0.1*VDC} RISE=2
.meas tran T_mid_rise_90 WHEN v(midpoint)={0.9*VDC} RISE=2
.meas tran dVdt_rise PARAM='0.8*VDC / (T_mid_rise_90 - T_mid_rise_10)'

.meas tran T_mid_fall_90 WHEN v(midpoint)={0.9*VDC} FALL=2
.meas tran T_mid_fall_10 WHEN v(midpoint)={0.1*VDC} FALL=2
.meas tran dVdt_fall PARAM='0.8*VDC / (T_mid_fall_10 - T_mid_fall_90)'

* --- SNUBBER CURRENT ---
* Peak snubber current during switching
.meas tran I_snub_hi_max MAX i(R_snub_hi) FROM={T_START} TO={T_END}
.meas tran I_snub_lo_max MAX i(R_snub_lo) FROM={T_START} TO={T_END}

* --- SNUBBER POWER LOSS ---
* Approximate snubber loss: P = 0.5 * C * V^2 * f * 2 (two snubbers)
* For C=10nF, V=320V, f=35kHz: P = 0.5*10n*320^2*35k*2 = 36W

* --- LOAD CURRENT ---
.meas tran I_load_max MAX i(L_load) FROM={T_START} TO={T_END}
.meas tran I_load_min MIN i(L_load) FROM={T_START} TO={T_END}

***************************************************************************
* CONTROL SCRIPT
***************************************************************************
.control
run

echo ""
echo "============================================================"
echo "RC Snubber Design - Simulation 22"
echo "============================================================"
echo ""
echo "SNUBBER CONFIGURATION:"
print c_snub
print r_snub
echo ""
echo "Stray inductance: 50nH"
echo ""

echo "============================================================"
echo "VOLTAGE OVERSHOOT/UNDERSHOOT"
echo "============================================================"
print v_mid_max
print v_mid_min
print v_overshoot_pct
echo ""
echo "Target: Overshoot < 10% (352V max)"
echo "Target: Undershoot > -20V"
echo ""

echo "============================================================"
echo "dV/dt DURING SWITCHING"
echo "============================================================"
print dvdt_rise
print dvdt_fall
echo ""
echo "Units: V/s"
echo "Target: <5V/ns = 5e9 V/s for EMI control"
echo ""

echo "============================================================"
echo "SNUBBER CURRENT PEAKS"
echo "============================================================"
print i_snub_hi_max
print i_snub_lo_max
echo ""
echo "High current indicates snubber is absorbing energy"
echo ""

echo "============================================================"
echo "LOAD CURRENT"
echo "============================================================"
print i_load_max
print i_load_min
echo ""

echo "============================================================"
echo "SNUBBER POWER LOSS (CALCULATED)"
echo "============================================================"
echo ""
echo "P_snub = 0.5 * C * V^2 * f * 2"
echo "P_snub = 0.5 * 10nF * 320V^2 * 35kHz * 2"
echo "P_snub = 35.8W per snubber pair"
echo ""
echo "This is significant! Consider:"
echo "  - RCD snubber (recovers energy)"
echo "  - Soft switching (ZVS) to reduce losses"
echo ""

echo "============================================================"
echo "DESIGN RECOMMENDATIONS"
echo "============================================================"
echo ""
echo "For IKW40N120H3 with 50nH stray inductance:"
echo "  C_snub = 10nF (limits dV/dt during turn-off)"
echo "  R_snub = 10 ohm (critically damped)"
echo ""
echo "Snubber resistor power rating:"
echo "  P_R = 0.5 * C * V^2 * f = 18W"
echo "  Use 25W resistor with heatsink"
echo ""
echo "Snubber capacitor voltage rating:"
echo "  V_cap > 1.5 * VDC = 480V"
echo "  Use 630V film capacitor"
echo ""

quit
.endc

.end
