*****************************************************************************
* Test Circuit: {test_name}
* Task: {task_id}
* Purpose: {purpose}
*****************************************************************************

.TITLE {title}

.INCLUDE {component_library}
