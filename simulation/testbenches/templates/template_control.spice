*------------------------------------------------------------------------------
* Control Block for automated measurement
*------------------------------------------------------------------------------
.control
{analysis_commands}
print {outputs}
{measurements}
.endc
