*------------------------------------------------------------------------------
* Control Block
*------------------------------------------------------------------------------
.control
{analysis_commands}
{outputs}
{measurements}
.endc
