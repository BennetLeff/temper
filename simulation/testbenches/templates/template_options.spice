*------------------------------------------------------------------------------
* Options for stable simulation
*------------------------------------------------------------------------------
.OPTIONS RELTOL=0.001 ABSTOL=1N VNTOL=1M
.OPTIONS ITL1=300 ITL4=100
.OPTIONS METHOD=TRAP
