*****************************************************************************
* Test Circuit: UCC21550 Dead Time
* Task: lesson-05
* Purpose: Dead Time Verification
*****************************************************************************

.TITLE UCC21550 Dead Time Verification

.INCLUDE
*------------------------------------------------------------------------------
* Simulation Options
*------------------------------------------------------------------------------
.OPTIONS RELTOL=0.001 ABSTOL=1N VNTOL=1M
.OPTIONS ITL1=300 ITL4=100
.OPTIONS METHOD=TRAP
* Parameters
.param DT_CAP=200p

* Behavioral Model
.subckt UCC21550 INA INB OUTA OUTB VDD2 GND2 PARAMS: CDEL=200p
* Inputs (Threshold 1.5V)
* Logic: A = INA & !INB (Interlock)
E_a_raw a_raw 0 VALUE={ 15 * (V(INA)>1.5) * (V(INB)<1.5) }
E_b_raw b_raw 0 VALUE={ 15 * (V(INB)>1.5) * (V(INA)<1.5) }

* Dead Time Generation (Rising Edge Delay)
R_dta a_raw a_del 1k
C_dta a_del 0 {CDEL}
D_dta a_del a_raw D_ideal

R_dtb b_raw b_del 1k
C_dtb b_del 0 {CDEL}
D_dtb b_del b_raw D_ideal

* Output Stage (Comparator)
E_outa OUTA GND2 VALUE={ (V(a_del)>7.5) ? V(VDD2) : 0 }
E_outb OUTB GND2 VALUE={ (V(b_del)>7.5) ? V(VDD2) : 0 }

.model D_ideal D(N=0.001 RS=0.1)
.ends

* Testbench
Vdd2 vdd2 0 DC 15
Vina ina 0 PULSE(0 3.3 1u 10n 10n 5u 10u)
Vinb inb 0 PULSE(0 3.3 6u 10n 10n 5u 10u)

X1 ina inb outa outb vdd2 0 UCC21550 PARAMS: CDEL={DT_CAP}

.tran 10n 12u*------------------------------------------------------------------------------
* Control Block
*------------------------------------------------------------------------------
.control
foreach val 100p 200p 500p 1000p 5.1n
  alterparam DT_CAP=$val
  reset
  run
* Measure Dead Time
meas tran t_deadtime TRIG v(outa) VAL=7.5 FALL=1 TARG v(outb) VAL=7.5 RISE=1
print t_deadtime

.endc
