* OVP-01 trip-point AND release-point transient: OVPComparator
* (elec/src/modules.ato), TLV3201 comparator model.
*
* CALIBRATED: false. No bench measurement exists for this circuit. Every
* component value below is copied read-only from the committed atopile
* source (elec/src/modules.ato: OVPComparator). Nothing here was invented
* to make the answer come out a particular way.
*
* Sourced values (read-only, elec/src/modules.ato: OVPComparator, as of the
* 2026-07-27 half-bus retune -- see docs/evidence/
* 2026-07-27-ovp01-half-bus-retune.md. The PRIOR r_ref_top=1100/r_hyst=287000
* values assumed this divider senses the FULL 340V bus; it senses the
* +170V HALF-bus (dc_bus_plus), so those values gave a ~399.8V trip at a
* node that never exceeds ~170V -- fail-open. Retuned to trip/hysteresis
* centred in HALF of the OVP-01 window (195-205V trip / 5-10V hysteresis,
* i.e. FUNCTIONAL_TEST_CRITERIA SS2.2's 390-410V/10-20V halved)):
*   - power_3v3 rail (comp.VCC):         3.3 V
*   - r_div_top1/top2/top3:              430 kohm each, in series (unchanged)
*   - r_div_bot:                         10000 ohm (unchanged)
*       -> V(comp.INP) = V_bus * 10000 / (3*430000 + 10000) = V_bus / 130
*   - r_ref_top:                         11800 ohm  -- CHANGED from 1100 ohm
*   - r_ref_bot:                         10000 ohm (unchanged)
*       -> V(comp.INN) = 3.3 * 10000 / (11800 + 10000) = 1.51376 V
*   - r_hyst:                            619000 ohm -- CHANGED from 287000
*     ohm, from comp.INP (the bus-sense node) back to comp.OUT. Unlike
*     ThermalComparator, the feedback lands on the SENSE side (INP) not
*     the reference side (INN), because the bus divider is what's
*     high-impedance here; see module comment "Feeding INN instead would
*     move the threshold the wrong way."
*
* Hand-derived pre-trip (rising) trip point, comp.OUT ~ 0V (fault not yet
* latched, so r_hyst pulls the sense node toward ground):
*   G = 1/1290000 + 1/10000 + 1/619000 = 1.01939e-4 S
*   V_bus_trip = V_ref / (G * 1290000) * ... equivalently, solving the INP
*   node equation for V_bus at V(INP)=V_ref=1.51376V:
*     (V_bus - V1)/1290000 + (0 - V1)/10000 + (0 - V1)/619000 = 0
*     V_bus = V1 * 1290000 * G = 1.51376 * 132.084 = 199.94 V
*   (module comment: trips 199.9V)
*
* Hand-derived post-trip (release, falling) point, comp.OUT ~ VCC = 3.3V
* (fault latched high via r_hyst positive feedback):
*     (V_bus - V1)/1290000 + (0 - V1)/10000 + (3.3 - V1)/619000 = 0
*     V_bus = V1*132.084 - 3.3*1290000/619000 = 199.94 - 6.88 = 193.06 V
*   (module comment: release 193.1V)
* Hysteresis (hand): ~6.9V, inside the halved OVP-01 5-10V requirement.
*
* What "v_bus.line" physically is
* --------------------------------
* main.ato wires `safety.dc_bus.line ~ dc_bus_plus`, the +170V HALF-bus,
* NOT dc_bus.line / the full bus (SUPERSEDED 2026-07-26 "resolution" --
* see run_ovp01_sim.py and docs/STRATEGY.md "OVP-01 senses the half-bus
* and is now fail-open" for why that resolution was wrong). This deck
* ramps that node directly and measures the trip/release thresholds at
* the node the comparator actually senses; the OVP-01 spec windows
* applied to this measurement are therefore the HALVED ones (195-205V /
* 5-10V), not the full-bus 390-410V/10-20V windows.
*
* Ramp: this deck drives v_bus UP past the trip point, THEN DOWN past the
* release point, in one transient run, so both thresholds are measured
* from the same latched comparator state (the release threshold only
* exists once the output has actually gone high via r_hyst).
*   0V -> 350V over 250us, then back down to 0V over the next 250us. 350V
*   gives >140V margin above the ~200V trip target (and above the 206.2V
*   worst-case corner), and returning to 0V gives full margin below the
*   ~193V release target.
*
* Known model-fidelity limit (simulation/models/TLV3201_ngspice.lib header):
* "It intentionally does not claim a timing, noise, or temperature model."
* This deck therefore measures only the DC/quasi-static trip and release
* THRESHOLDS, not response time.

.include ../../models/TLV3201_ngspice.lib

.param RAMP_MAX_V=350
.param T_UP=250u
.param T_DOWN=250u

V_VCC VCC_3V3 0 DC 3.3
V_BUS v_bus 0 PWL(0 0 {T_UP} {RAMP_MAX_V} {T_UP+T_DOWN} 0)

R_DIV_TOP1 v_bus n1 430000
R_DIV_TOP2 n1 n2 430000
R_DIV_TOP3 n2 vinp 430000
R_DIV_BOT vinp 0 10000

R_REF_TOP VCC_3V3 vinn 11800
R_REF_BOT vinn 0 10000

* Hysteresis: positive feedback from output to INP (bus-sense node)
R_HYST vinp comp_out 619000

X_COMP vinp vinn VCC_3V3 0 comp_out TLV3201_NGSPICE

.control
set noaskquit
tran 100n 500u
meas tran t_trip WHEN v(comp_out)=1.65 RISE=1
meas tran t_release WHEN v(comp_out)=1.65 FALL=1
meas tran v_bus_at_trip FIND v(v_bus) AT={t_trip}
meas tran v_bus_at_release FIND v(v_bus) AT={t_release}
print t_trip
print t_release
print v_bus_at_trip
print v_bus_at_release
quit
.endc

.end
