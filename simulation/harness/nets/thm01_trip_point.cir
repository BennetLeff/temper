* THM-01 trip-point AND recovery-point transient: ThermalComparator
* (elec/src/modules.ato), TLV3201 comparator model, NTC modeled via its own
* Beta equation.
*
* CALIBRATED: false. No bench measurement exists for this circuit. Every
* component/thermistor value below is copied read-only from the committed
* atopile source (elec/src/modules.ato: ThermalComparator). Nothing here
* was invented to make the answer come out a particular way.
*
* Sourced values (read-only, elec/src/modules.ato: ThermalComparator, as
* re-proportioned to restore the recovery/hysteresis requirement that had
* been dropped from the summary table -- see module comment "An earlier
* revision used 9.53k/10k/100k, giving only 5.6C" [of hysteresis]):
*   - power_3v3 rail:            3.3 V
*   - NTC (ntc.mpn = "NTCALUG01A104GA"): R25 = 100 kohm, B25/85 = 4190 K
*     (module's own inline comment, citing the datasheet part number).
*   - r_ntc_fixed:                 10000 ohm (top of NTC divider, unchanged)
*   - r_ref_top / r_ref_bot:        9090 / 11500 ohm (reference divider --
*     CHANGED from 9530/10000)
*   - r_hyst:                       34800 ohm, from comp.INP back to comp.OUT
*     (positive-feedback hysteresis -- CHANGED from 100000 ohm)
*
* NTC model: Beta (B-parameter) equation, not a datasheet Steinhart-Hart
* table (none is committed anywhere in this repo for this part number):
*     R(T) = R25 * exp( B * (1/T - 1/T25) ),  T in kelvin, T25 = 298.15 K
* implemented as a temperature-controlled nonlinear resistor to ground via
* an ngspice B-source, driven by an independent "temperature" voltage
* source V_TEMP (units: kelvin). This is an idealized ramped proxy signal,
* not a simulation of heatsink thermal mass or the NTC's own thermal time
* constant.
*
* Divider topology (as committed):
*   VCC -> r_ntc_fixed -> ntc_sense -> NTC(T) -> GND     (comp.INN = ntc_sense)
*   VCC -> r_ref_top -> comp.INP -> r_ref_bot -> GND     (reference)
*   comp.INP -> r_hyst -> comp.OUT
*
* Hand-derived pre-trip reference (comp.OUT ~ 0V, so r_hyst || r_ref_bot to
* ground while the fault has not yet latched):
*   G = 1/9090 + 1/11500 + 1/34800 = 2.24703e-4 S
*   V_ref_pretrip = (3.3/9090) / G = 1.6156 V
*   R_ntc_trip = V_ref_pretrip * 10000 / (3.3 - V_ref_pretrip) = 9593 ohm
*   T_trip = 1 / (1/298.15 + ln(9593/100000)/4190) = 357.8 K = 84.7 degC
*   (module's own comment states 85.0 degC with more precise arithmetic;
*   this deck's SPICE result, not either hand estimate, is the value of
*   record.)
*
* Hand-derived post-trip (release) reference (comp.OUT ~ VCC = 3.3V, output
* has latched high via r_hyst positive feedback):
*   V_ref_release = (3.3/9090 + 3.3/34800) / G = 2.0372 V
*   R_ntc_release = V_ref_release * 10000 / (3.3 - V_ref_release) = 16131 ohm
*   T_release = 1 / (1/298.15 + ln(16131/100000)/4190) = 342.6 K = 69.5 degC
*   (module comment: 69.8 degC.)
* Hysteresis (hand): ~15.2 degC, inside the THM-01 requirement of an 85C
* trip / 70C recovery (FUNCTIONAL_TEST_CRITERIA.md SS2.3).
*
* Ramp: this deck drives temperature UP past the trip point, THEN DOWN past
* the release point, in one transient run, so both thresholds are measured
* together from the same latched comparator state (the release threshold
* only exists once the output has actually gone high via r_hyst -- it is
* not a property of the divider alone).
*   25 degC (298.15K) -> 150 degC (423.15K) over 300us, then back down to
*   25 degC (298.15K) over the next 300us. 150C gives ~65C margin above the
*   85C trip target and the return to 25C gives ~45C margin below the 70C
*   recovery target, so both crossings land well inside the ramp, not at
*   its edges.
*
* Known model-fidelity limit (TLV3201_ngspice.lib): no timing model. This
* deck measures only the DC/quasi-static trip and release THRESHOLDS, not
* response time.

.include ../../models/TLV3201_ngspice.lib

.param T_START=298.15
.param T_PEAK=423.15
.param T_UP=300u
.param T_DOWN=300u
.param T_TOTAL=600u

V_VCC VCC_3V3 0 DC 3.3
V_TEMP temp_k 0 PWL(0 {T_START} {T_UP} {T_PEAK} {T_TOTAL} {T_START})

R_NTC_FIXED VCC_3V3 ntc_sense 10000
* NTC to ground: nonlinear resistor via Beta equation, R25=100k, B=4190K
B_NTC ntc_sense 0 I=V(ntc_sense,0)/(100000*exp(4190*((1/V(temp_k))-(1/298.15))))

R_REF_TOP VCC_3V3 vinp 9090
R_REF_BOT vinp 0 11500
R_HYST vinp comp_out 34800

X_COMP vinp ntc_sense VCC_3V3 0 comp_out TLV3201_NGSPICE

.control
set noaskquit
tran 100n 600u
meas tran t_trip WHEN v(comp_out)=1.65 RISE=1
meas tran t_release WHEN v(comp_out)=1.65 FALL=1
meas tran v_ntc_sense_at_trip FIND v(ntc_sense) AT={t_trip}
meas tran v_ntc_sense_at_release FIND v(ntc_sense) AT={t_release}
meas tran temp_k_at_trip FIND v(temp_k) AT={t_trip}
meas tran temp_k_at_release FIND v(temp_k) AT={t_release}
print t_trip
print t_release
print v_ntc_sense_at_trip
print v_ntc_sense_at_release
print temp_k_at_trip
print temp_k_at_release
quit
.endc

.end
