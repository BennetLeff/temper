datasheet_holdout
* Exploratory LMR51430XDDCR behavioral simulation; not qualification.
.include ../model.lib
VIN in 0 PWL(0 0 10u 12 12m 12)
R_SOURCE in vin_node 100m
C_IN vin_node 0 2.2u
V_LOAD out load 0
R_LOAD load 0 1.666666667
R_ESR out cap 5m
C_OUT cap 0 44u
C_HF out 0 100n
L_OUT sw l_out 6.8u
R_DCR l_out out 8.5m
R_FBTOP out fb 100k
R_FBBOT fb 0 13.7k
C_BOOT boot sw 100n
X_U1 vin_node sw 0 fb vin_node boot LMR51430XDDCR
.save time v(out) v(in) v(vin_node) i(VIN) i(V_LOAD) v(fb) v(sw) v(cap) v(x_u1.ref) v(x_u1.ctrl) v(x_u1.ipk) v(x_u1.gh) v(x_u1.gl) i(L_OUT)
.options method=gear reltol=1e-4 abstol=1e-9 vntol=1e-6
.temp 25
.tran 20n 12m 0 20n uic

.control
set filetype=binary
run
let pin = -v(in)*i(vin)
let pout = v(out)*i(v_load)
let gate_overlap = v(x_u1.gh)*v(x_u1.gl)/25
meas tran vout_avg AVG v(out) from=10m to=12m
meas tran vout_min MIN v(out) from=10m to=12m
meas tran vout_max MAX v(out) from=10m to=12m
meas tran il_avg AVG i(l_out) from=10m to=12m
meas tran il_min MIN i(l_out) from=10m to=12m
meas tran il_max MAX i(l_out) from=10m to=12m
meas tran pin_avg AVG pin from=10m to=12m
meas tran pout_avg AVG pout from=10m to=12m
meas tran gate_overlap_max MAX gate_overlap from=0 to=12m
meas tran vout_before AVG v(out) from=5m to=5.9m
meas tran vout_loaded AVG v(out) from=7.5m to=8.5m
meas tran transition_low MIN v(out) from=6m to=6.5m
meas tran transition_high MAX v(out) from=9m to=9.5m
meas tran switching_span TRIG v(x_u1.gh) val=2.5 rise=1 td=10m TARG v(x_u1.gh) val=2.5 rise=101 td=10m
write waveform.raw all
quit
.endc

.end
